* Macro write/read smoke testbench -- sram_256x32 top netlist (issue #203).
* GENERATED by sim/macro-smoke/smoke.py gen -- do not hand-edit.
*
* Claim: after a write, a read of the same address returns the written word;
* a per-bit-masked write changes only the unmasked bits; a read of another
* address is unaffected; Q holds across writes and idle cycles. FUNCTIONAL
* ONLY: one corner, no timing, no margin, no Monte Carlo. No cycle time or
* clock-to-Q is claimed (spec/periphery-architecture.md, 'What this record
* does not do'). The PVT characterisation stays with sim/read-snm, hold-snm,
* write-margin and access-time; this is not a signoff result.
*
* DUT: design/netlist/sram_256x32.spice -- the macro top, periphery in full
* (decoder, control, 32 I/O slices, 4:1 mux). The ONE substitution: run.sh
* copies that netlist into the scratch dir as ./sram_256x32.noarray.spice with
* the `.subckt sram_64x128_array` block deleted (ngspice keeps the FIRST of
* two same-named subckts, so it cannot be overridden), and the array is
* redefined below with only the rows this test addresses populated (the full
* 8,192-cell transient did not finish in 10 min on a shared host). Every bit line carries a lumped
* 20 fF stand-in for the other rows, the same single-number placeholder
* sim/access-time/ uses (real column C is layout-derived, #204/#205). There is
* NO wire RC on wordlines or bit lines, so this says nothing about the
* wordline RC gate (periphery record, 'Wordline RC gate').
* `@@REPO_ROOT@@` is substituted by run.sh, as in the other testbenches.
.include './corner.inc'
VVDD VDD 0 DC VDDC
VVSS VSS 0 DC 0
.include './sram_256x32.noarray.spice'
.subckt sram_64x128_array WL0 WL1 WL2 WL3 WL4 WL5 WL6 WL7 WL8 WL9 WL10 WL11 WL12 WL13 WL14 WL15 WL16 WL17 WL18 WL19 WL20 WL21 WL22 WL23 WL24 WL25 WL26 WL27 WL28 WL29 WL30 WL31 WL32 WL33 WL34 WL35 WL36 WL37 WL38 WL39 WL40 WL41 WL42 WL43 WL44 WL45 WL46 WL47 WL48 WL49 WL50 WL51 WL52 WL53 WL54 WL55 WL56 WL57 WL58 WL59 WL60 WL61 WL62 WL63 BL0 BLB0 BL1 BLB1 BL2 BLB2 BL3 BLB3 BL4 BLB4 BL5 BLB5 BL6 BLB6 BL7 BLB7 BL8 BLB8 BL9 BLB9 BL10 BLB10 BL11 BLB11 BL12 BLB12 BL13 BLB13 BL14 BLB14 BL15 BLB15 BL16 BLB16 BL17 BLB17 BL18 BLB18 BL19 BLB19 BL20 BLB20 BL21 BLB21 BL22 BLB22 BL23 BLB23 BL24 BLB24 BL25 BLB25 BL26 BLB26 BL27 BLB27 BL28 BLB28 BL29 BLB29 BL30 BLB30 BL31 BLB31 BL32 BLB32 BL33 BLB33 BL34 BLB34 BL35 BLB35 BL36 BLB36 BL37 BLB37 BL38 BLB38 BL39 BLB39 BL40 BLB40 BL41 BLB41 BL42 BLB42 BL43 BLB43 BL44 BLB44 BL45 BLB45 BL46 BLB46 BL47 BLB47 BL48 BLB48 BL49 BLB49 BL50 BLB50 BL51 BLB51 BL52 BLB52 BL53 BLB53 BL54 BLB54 BL55 BLB55 BL56 BLB56 BL57 BLB57 BL58 BLB58 BL59 BLB59 BL60 BLB60 BL61 BLB61 BL62 BLB62 BL63 BLB63 BL64 BLB64 BL65 BLB65 BL66 BLB66 BL67 BLB67 BL68 BLB68 BL69 BLB69 BL70 BLB70 BL71 BLB71 BL72 BLB72 BL73 BLB73 BL74 BLB74 BL75 BLB75 BL76 BLB76 BL77 BLB77 BL78 BLB78 BL79 BLB79 BL80 BLB80 BL81 BLB81 BL82 BLB82 BL83 BLB83 BL84 BLB84 BL85 BLB85 BL86 BLB86 BL87 BLB87 BL88 BLB88 BL89 BLB89 BL90 BLB90 BL91 BLB91 BL92 BLB92 BL93 BLB93 BL94 BLB94 BL95 BLB95 BL96 BLB96 BL97 BLB97 BL98 BLB98 BL99 BLB99 BL100 BLB100 BL101 BLB101 BL102 BLB102 BL103 BLB103 BL104 BLB104 BL105 BLB105 BL106 BLB106 BL107 BLB107 BL108 BLB108 BL109 BLB109 BL110 BLB110 BL111 BLB111 BL112 BLB112 BL113 BLB113 BL114 BLB114 BL115 BLB115 BL116 BLB116 BL117 BLB117 BL118 BLB118 BL119 BLB119 BL120 BLB120 BL121 BLB121 BL122 BLB122 BL123 BLB123 BL124 BLB124 BL125 BLB125 BL126 BLB126 BL127 BLB127 VDD VSS
Xr0c0 BL0 BLB0 WL0 VDD VSS bitcell_6t
Xr0c1 BL1 BLB1 WL0 VDD VSS bitcell_6t
Xr0c2 BL2 BLB2 WL0 VDD VSS bitcell_6t
Xr0c3 BL3 BLB3 WL0 VDD VSS bitcell_6t
Xr0c4 BL4 BLB4 WL0 VDD VSS bitcell_6t
Xr0c5 BL5 BLB5 WL0 VDD VSS bitcell_6t
Xr0c6 BL6 BLB6 WL0 VDD VSS bitcell_6t
Xr0c7 BL7 BLB7 WL0 VDD VSS bitcell_6t
Xr0c8 BL8 BLB8 WL0 VDD VSS bitcell_6t
Xr0c9 BL9 BLB9 WL0 VDD VSS bitcell_6t
Xr0c10 BL10 BLB10 WL0 VDD VSS bitcell_6t
Xr0c11 BL11 BLB11 WL0 VDD VSS bitcell_6t
Xr0c12 BL12 BLB12 WL0 VDD VSS bitcell_6t
Xr0c13 BL13 BLB13 WL0 VDD VSS bitcell_6t
Xr0c14 BL14 BLB14 WL0 VDD VSS bitcell_6t
Xr0c15 BL15 BLB15 WL0 VDD VSS bitcell_6t
Xr0c16 BL16 BLB16 WL0 VDD VSS bitcell_6t
Xr0c17 BL17 BLB17 WL0 VDD VSS bitcell_6t
Xr0c18 BL18 BLB18 WL0 VDD VSS bitcell_6t
Xr0c19 BL19 BLB19 WL0 VDD VSS bitcell_6t
Xr0c20 BL20 BLB20 WL0 VDD VSS bitcell_6t
Xr0c21 BL21 BLB21 WL0 VDD VSS bitcell_6t
Xr0c22 BL22 BLB22 WL0 VDD VSS bitcell_6t
Xr0c23 BL23 BLB23 WL0 VDD VSS bitcell_6t
Xr0c24 BL24 BLB24 WL0 VDD VSS bitcell_6t
Xr0c25 BL25 BLB25 WL0 VDD VSS bitcell_6t
Xr0c26 BL26 BLB26 WL0 VDD VSS bitcell_6t
Xr0c27 BL27 BLB27 WL0 VDD VSS bitcell_6t
Xr0c28 BL28 BLB28 WL0 VDD VSS bitcell_6t
Xr0c29 BL29 BLB29 WL0 VDD VSS bitcell_6t
Xr0c30 BL30 BLB30 WL0 VDD VSS bitcell_6t
Xr0c31 BL31 BLB31 WL0 VDD VSS bitcell_6t
Xr0c32 BL32 BLB32 WL0 VDD VSS bitcell_6t
Xr0c33 BL33 BLB33 WL0 VDD VSS bitcell_6t
Xr0c34 BL34 BLB34 WL0 VDD VSS bitcell_6t
Xr0c35 BL35 BLB35 WL0 VDD VSS bitcell_6t
Xr0c36 BL36 BLB36 WL0 VDD VSS bitcell_6t
Xr0c37 BL37 BLB37 WL0 VDD VSS bitcell_6t
Xr0c38 BL38 BLB38 WL0 VDD VSS bitcell_6t
Xr0c39 BL39 BLB39 WL0 VDD VSS bitcell_6t
Xr0c40 BL40 BLB40 WL0 VDD VSS bitcell_6t
Xr0c41 BL41 BLB41 WL0 VDD VSS bitcell_6t
Xr0c42 BL42 BLB42 WL0 VDD VSS bitcell_6t
Xr0c43 BL43 BLB43 WL0 VDD VSS bitcell_6t
Xr0c44 BL44 BLB44 WL0 VDD VSS bitcell_6t
Xr0c45 BL45 BLB45 WL0 VDD VSS bitcell_6t
Xr0c46 BL46 BLB46 WL0 VDD VSS bitcell_6t
Xr0c47 BL47 BLB47 WL0 VDD VSS bitcell_6t
Xr0c48 BL48 BLB48 WL0 VDD VSS bitcell_6t
Xr0c49 BL49 BLB49 WL0 VDD VSS bitcell_6t
Xr0c50 BL50 BLB50 WL0 VDD VSS bitcell_6t
Xr0c51 BL51 BLB51 WL0 VDD VSS bitcell_6t
Xr0c52 BL52 BLB52 WL0 VDD VSS bitcell_6t
Xr0c53 BL53 BLB53 WL0 VDD VSS bitcell_6t
Xr0c54 BL54 BLB54 WL0 VDD VSS bitcell_6t
Xr0c55 BL55 BLB55 WL0 VDD VSS bitcell_6t
Xr0c56 BL56 BLB56 WL0 VDD VSS bitcell_6t
Xr0c57 BL57 BLB57 WL0 VDD VSS bitcell_6t
Xr0c58 BL58 BLB58 WL0 VDD VSS bitcell_6t
Xr0c59 BL59 BLB59 WL0 VDD VSS bitcell_6t
Xr0c60 BL60 BLB60 WL0 VDD VSS bitcell_6t
Xr0c61 BL61 BLB61 WL0 VDD VSS bitcell_6t
Xr0c62 BL62 BLB62 WL0 VDD VSS bitcell_6t
Xr0c63 BL63 BLB63 WL0 VDD VSS bitcell_6t
Xr0c64 BL64 BLB64 WL0 VDD VSS bitcell_6t
Xr0c65 BL65 BLB65 WL0 VDD VSS bitcell_6t
Xr0c66 BL66 BLB66 WL0 VDD VSS bitcell_6t
Xr0c67 BL67 BLB67 WL0 VDD VSS bitcell_6t
Xr0c68 BL68 BLB68 WL0 VDD VSS bitcell_6t
Xr0c69 BL69 BLB69 WL0 VDD VSS bitcell_6t
Xr0c70 BL70 BLB70 WL0 VDD VSS bitcell_6t
Xr0c71 BL71 BLB71 WL0 VDD VSS bitcell_6t
Xr0c72 BL72 BLB72 WL0 VDD VSS bitcell_6t
Xr0c73 BL73 BLB73 WL0 VDD VSS bitcell_6t
Xr0c74 BL74 BLB74 WL0 VDD VSS bitcell_6t
Xr0c75 BL75 BLB75 WL0 VDD VSS bitcell_6t
Xr0c76 BL76 BLB76 WL0 VDD VSS bitcell_6t
Xr0c77 BL77 BLB77 WL0 VDD VSS bitcell_6t
Xr0c78 BL78 BLB78 WL0 VDD VSS bitcell_6t
Xr0c79 BL79 BLB79 WL0 VDD VSS bitcell_6t
Xr0c80 BL80 BLB80 WL0 VDD VSS bitcell_6t
Xr0c81 BL81 BLB81 WL0 VDD VSS bitcell_6t
Xr0c82 BL82 BLB82 WL0 VDD VSS bitcell_6t
Xr0c83 BL83 BLB83 WL0 VDD VSS bitcell_6t
Xr0c84 BL84 BLB84 WL0 VDD VSS bitcell_6t
Xr0c85 BL85 BLB85 WL0 VDD VSS bitcell_6t
Xr0c86 BL86 BLB86 WL0 VDD VSS bitcell_6t
Xr0c87 BL87 BLB87 WL0 VDD VSS bitcell_6t
Xr0c88 BL88 BLB88 WL0 VDD VSS bitcell_6t
Xr0c89 BL89 BLB89 WL0 VDD VSS bitcell_6t
Xr0c90 BL90 BLB90 WL0 VDD VSS bitcell_6t
Xr0c91 BL91 BLB91 WL0 VDD VSS bitcell_6t
Xr0c92 BL92 BLB92 WL0 VDD VSS bitcell_6t
Xr0c93 BL93 BLB93 WL0 VDD VSS bitcell_6t
Xr0c94 BL94 BLB94 WL0 VDD VSS bitcell_6t
Xr0c95 BL95 BLB95 WL0 VDD VSS bitcell_6t
Xr0c96 BL96 BLB96 WL0 VDD VSS bitcell_6t
Xr0c97 BL97 BLB97 WL0 VDD VSS bitcell_6t
Xr0c98 BL98 BLB98 WL0 VDD VSS bitcell_6t
Xr0c99 BL99 BLB99 WL0 VDD VSS bitcell_6t
Xr0c100 BL100 BLB100 WL0 VDD VSS bitcell_6t
Xr0c101 BL101 BLB101 WL0 VDD VSS bitcell_6t
Xr0c102 BL102 BLB102 WL0 VDD VSS bitcell_6t
Xr0c103 BL103 BLB103 WL0 VDD VSS bitcell_6t
Xr0c104 BL104 BLB104 WL0 VDD VSS bitcell_6t
Xr0c105 BL105 BLB105 WL0 VDD VSS bitcell_6t
Xr0c106 BL106 BLB106 WL0 VDD VSS bitcell_6t
Xr0c107 BL107 BLB107 WL0 VDD VSS bitcell_6t
Xr0c108 BL108 BLB108 WL0 VDD VSS bitcell_6t
Xr0c109 BL109 BLB109 WL0 VDD VSS bitcell_6t
Xr0c110 BL110 BLB110 WL0 VDD VSS bitcell_6t
Xr0c111 BL111 BLB111 WL0 VDD VSS bitcell_6t
Xr0c112 BL112 BLB112 WL0 VDD VSS bitcell_6t
Xr0c113 BL113 BLB113 WL0 VDD VSS bitcell_6t
Xr0c114 BL114 BLB114 WL0 VDD VSS bitcell_6t
Xr0c115 BL115 BLB115 WL0 VDD VSS bitcell_6t
Xr0c116 BL116 BLB116 WL0 VDD VSS bitcell_6t
Xr0c117 BL117 BLB117 WL0 VDD VSS bitcell_6t
Xr0c118 BL118 BLB118 WL0 VDD VSS bitcell_6t
Xr0c119 BL119 BLB119 WL0 VDD VSS bitcell_6t
Xr0c120 BL120 BLB120 WL0 VDD VSS bitcell_6t
Xr0c121 BL121 BLB121 WL0 VDD VSS bitcell_6t
Xr0c122 BL122 BLB122 WL0 VDD VSS bitcell_6t
Xr0c123 BL123 BLB123 WL0 VDD VSS bitcell_6t
Xr0c124 BL124 BLB124 WL0 VDD VSS bitcell_6t
Xr0c125 BL125 BLB125 WL0 VDD VSS bitcell_6t
Xr0c126 BL126 BLB126 WL0 VDD VSS bitcell_6t
Xr0c127 BL127 BLB127 WL0 VDD VSS bitcell_6t
Xr15c0 BL0 BLB0 WL15 VDD VSS bitcell_6t
Xr15c1 BL1 BLB1 WL15 VDD VSS bitcell_6t
Xr15c2 BL2 BLB2 WL15 VDD VSS bitcell_6t
Xr15c3 BL3 BLB3 WL15 VDD VSS bitcell_6t
Xr15c4 BL4 BLB4 WL15 VDD VSS bitcell_6t
Xr15c5 BL5 BLB5 WL15 VDD VSS bitcell_6t
Xr15c6 BL6 BLB6 WL15 VDD VSS bitcell_6t
Xr15c7 BL7 BLB7 WL15 VDD VSS bitcell_6t
Xr15c8 BL8 BLB8 WL15 VDD VSS bitcell_6t
Xr15c9 BL9 BLB9 WL15 VDD VSS bitcell_6t
Xr15c10 BL10 BLB10 WL15 VDD VSS bitcell_6t
Xr15c11 BL11 BLB11 WL15 VDD VSS bitcell_6t
Xr15c12 BL12 BLB12 WL15 VDD VSS bitcell_6t
Xr15c13 BL13 BLB13 WL15 VDD VSS bitcell_6t
Xr15c14 BL14 BLB14 WL15 VDD VSS bitcell_6t
Xr15c15 BL15 BLB15 WL15 VDD VSS bitcell_6t
Xr15c16 BL16 BLB16 WL15 VDD VSS bitcell_6t
Xr15c17 BL17 BLB17 WL15 VDD VSS bitcell_6t
Xr15c18 BL18 BLB18 WL15 VDD VSS bitcell_6t
Xr15c19 BL19 BLB19 WL15 VDD VSS bitcell_6t
Xr15c20 BL20 BLB20 WL15 VDD VSS bitcell_6t
Xr15c21 BL21 BLB21 WL15 VDD VSS bitcell_6t
Xr15c22 BL22 BLB22 WL15 VDD VSS bitcell_6t
Xr15c23 BL23 BLB23 WL15 VDD VSS bitcell_6t
Xr15c24 BL24 BLB24 WL15 VDD VSS bitcell_6t
Xr15c25 BL25 BLB25 WL15 VDD VSS bitcell_6t
Xr15c26 BL26 BLB26 WL15 VDD VSS bitcell_6t
Xr15c27 BL27 BLB27 WL15 VDD VSS bitcell_6t
Xr15c28 BL28 BLB28 WL15 VDD VSS bitcell_6t
Xr15c29 BL29 BLB29 WL15 VDD VSS bitcell_6t
Xr15c30 BL30 BLB30 WL15 VDD VSS bitcell_6t
Xr15c31 BL31 BLB31 WL15 VDD VSS bitcell_6t
Xr15c32 BL32 BLB32 WL15 VDD VSS bitcell_6t
Xr15c33 BL33 BLB33 WL15 VDD VSS bitcell_6t
Xr15c34 BL34 BLB34 WL15 VDD VSS bitcell_6t
Xr15c35 BL35 BLB35 WL15 VDD VSS bitcell_6t
Xr15c36 BL36 BLB36 WL15 VDD VSS bitcell_6t
Xr15c37 BL37 BLB37 WL15 VDD VSS bitcell_6t
Xr15c38 BL38 BLB38 WL15 VDD VSS bitcell_6t
Xr15c39 BL39 BLB39 WL15 VDD VSS bitcell_6t
Xr15c40 BL40 BLB40 WL15 VDD VSS bitcell_6t
Xr15c41 BL41 BLB41 WL15 VDD VSS bitcell_6t
Xr15c42 BL42 BLB42 WL15 VDD VSS bitcell_6t
Xr15c43 BL43 BLB43 WL15 VDD VSS bitcell_6t
Xr15c44 BL44 BLB44 WL15 VDD VSS bitcell_6t
Xr15c45 BL45 BLB45 WL15 VDD VSS bitcell_6t
Xr15c46 BL46 BLB46 WL15 VDD VSS bitcell_6t
Xr15c47 BL47 BLB47 WL15 VDD VSS bitcell_6t
Xr15c48 BL48 BLB48 WL15 VDD VSS bitcell_6t
Xr15c49 BL49 BLB49 WL15 VDD VSS bitcell_6t
Xr15c50 BL50 BLB50 WL15 VDD VSS bitcell_6t
Xr15c51 BL51 BLB51 WL15 VDD VSS bitcell_6t
Xr15c52 BL52 BLB52 WL15 VDD VSS bitcell_6t
Xr15c53 BL53 BLB53 WL15 VDD VSS bitcell_6t
Xr15c54 BL54 BLB54 WL15 VDD VSS bitcell_6t
Xr15c55 BL55 BLB55 WL15 VDD VSS bitcell_6t
Xr15c56 BL56 BLB56 WL15 VDD VSS bitcell_6t
Xr15c57 BL57 BLB57 WL15 VDD VSS bitcell_6t
Xr15c58 BL58 BLB58 WL15 VDD VSS bitcell_6t
Xr15c59 BL59 BLB59 WL15 VDD VSS bitcell_6t
Xr15c60 BL60 BLB60 WL15 VDD VSS bitcell_6t
Xr15c61 BL61 BLB61 WL15 VDD VSS bitcell_6t
Xr15c62 BL62 BLB62 WL15 VDD VSS bitcell_6t
Xr15c63 BL63 BLB63 WL15 VDD VSS bitcell_6t
Xr15c64 BL64 BLB64 WL15 VDD VSS bitcell_6t
Xr15c65 BL65 BLB65 WL15 VDD VSS bitcell_6t
Xr15c66 BL66 BLB66 WL15 VDD VSS bitcell_6t
Xr15c67 BL67 BLB67 WL15 VDD VSS bitcell_6t
Xr15c68 BL68 BLB68 WL15 VDD VSS bitcell_6t
Xr15c69 BL69 BLB69 WL15 VDD VSS bitcell_6t
Xr15c70 BL70 BLB70 WL15 VDD VSS bitcell_6t
Xr15c71 BL71 BLB71 WL15 VDD VSS bitcell_6t
Xr15c72 BL72 BLB72 WL15 VDD VSS bitcell_6t
Xr15c73 BL73 BLB73 WL15 VDD VSS bitcell_6t
Xr15c74 BL74 BLB74 WL15 VDD VSS bitcell_6t
Xr15c75 BL75 BLB75 WL15 VDD VSS bitcell_6t
Xr15c76 BL76 BLB76 WL15 VDD VSS bitcell_6t
Xr15c77 BL77 BLB77 WL15 VDD VSS bitcell_6t
Xr15c78 BL78 BLB78 WL15 VDD VSS bitcell_6t
Xr15c79 BL79 BLB79 WL15 VDD VSS bitcell_6t
Xr15c80 BL80 BLB80 WL15 VDD VSS bitcell_6t
Xr15c81 BL81 BLB81 WL15 VDD VSS bitcell_6t
Xr15c82 BL82 BLB82 WL15 VDD VSS bitcell_6t
Xr15c83 BL83 BLB83 WL15 VDD VSS bitcell_6t
Xr15c84 BL84 BLB84 WL15 VDD VSS bitcell_6t
Xr15c85 BL85 BLB85 WL15 VDD VSS bitcell_6t
Xr15c86 BL86 BLB86 WL15 VDD VSS bitcell_6t
Xr15c87 BL87 BLB87 WL15 VDD VSS bitcell_6t
Xr15c88 BL88 BLB88 WL15 VDD VSS bitcell_6t
Xr15c89 BL89 BLB89 WL15 VDD VSS bitcell_6t
Xr15c90 BL90 BLB90 WL15 VDD VSS bitcell_6t
Xr15c91 BL91 BLB91 WL15 VDD VSS bitcell_6t
Xr15c92 BL92 BLB92 WL15 VDD VSS bitcell_6t
Xr15c93 BL93 BLB93 WL15 VDD VSS bitcell_6t
Xr15c94 BL94 BLB94 WL15 VDD VSS bitcell_6t
Xr15c95 BL95 BLB95 WL15 VDD VSS bitcell_6t
Xr15c96 BL96 BLB96 WL15 VDD VSS bitcell_6t
Xr15c97 BL97 BLB97 WL15 VDD VSS bitcell_6t
Xr15c98 BL98 BLB98 WL15 VDD VSS bitcell_6t
Xr15c99 BL99 BLB99 WL15 VDD VSS bitcell_6t
Xr15c100 BL100 BLB100 WL15 VDD VSS bitcell_6t
Xr15c101 BL101 BLB101 WL15 VDD VSS bitcell_6t
Xr15c102 BL102 BLB102 WL15 VDD VSS bitcell_6t
Xr15c103 BL103 BLB103 WL15 VDD VSS bitcell_6t
Xr15c104 BL104 BLB104 WL15 VDD VSS bitcell_6t
Xr15c105 BL105 BLB105 WL15 VDD VSS bitcell_6t
Xr15c106 BL106 BLB106 WL15 VDD VSS bitcell_6t
Xr15c107 BL107 BLB107 WL15 VDD VSS bitcell_6t
Xr15c108 BL108 BLB108 WL15 VDD VSS bitcell_6t
Xr15c109 BL109 BLB109 WL15 VDD VSS bitcell_6t
Xr15c110 BL110 BLB110 WL15 VDD VSS bitcell_6t
Xr15c111 BL111 BLB111 WL15 VDD VSS bitcell_6t
Xr15c112 BL112 BLB112 WL15 VDD VSS bitcell_6t
Xr15c113 BL113 BLB113 WL15 VDD VSS bitcell_6t
Xr15c114 BL114 BLB114 WL15 VDD VSS bitcell_6t
Xr15c115 BL115 BLB115 WL15 VDD VSS bitcell_6t
Xr15c116 BL116 BLB116 WL15 VDD VSS bitcell_6t
Xr15c117 BL117 BLB117 WL15 VDD VSS bitcell_6t
Xr15c118 BL118 BLB118 WL15 VDD VSS bitcell_6t
Xr15c119 BL119 BLB119 WL15 VDD VSS bitcell_6t
Xr15c120 BL120 BLB120 WL15 VDD VSS bitcell_6t
Xr15c121 BL121 BLB121 WL15 VDD VSS bitcell_6t
Xr15c122 BL122 BLB122 WL15 VDD VSS bitcell_6t
Xr15c123 BL123 BLB123 WL15 VDD VSS bitcell_6t
Xr15c124 BL124 BLB124 WL15 VDD VSS bitcell_6t
Xr15c125 BL125 BLB125 WL15 VDD VSS bitcell_6t
Xr15c126 BL126 BLB126 WL15 VDD VSS bitcell_6t
Xr15c127 BL127 BLB127 WL15 VDD VSS bitcell_6t
Xr41c0 BL0 BLB0 WL41 VDD VSS bitcell_6t
Xr41c1 BL1 BLB1 WL41 VDD VSS bitcell_6t
Xr41c2 BL2 BLB2 WL41 VDD VSS bitcell_6t
Xr41c3 BL3 BLB3 WL41 VDD VSS bitcell_6t
Xr41c4 BL4 BLB4 WL41 VDD VSS bitcell_6t
Xr41c5 BL5 BLB5 WL41 VDD VSS bitcell_6t
Xr41c6 BL6 BLB6 WL41 VDD VSS bitcell_6t
Xr41c7 BL7 BLB7 WL41 VDD VSS bitcell_6t
Xr41c8 BL8 BLB8 WL41 VDD VSS bitcell_6t
Xr41c9 BL9 BLB9 WL41 VDD VSS bitcell_6t
Xr41c10 BL10 BLB10 WL41 VDD VSS bitcell_6t
Xr41c11 BL11 BLB11 WL41 VDD VSS bitcell_6t
Xr41c12 BL12 BLB12 WL41 VDD VSS bitcell_6t
Xr41c13 BL13 BLB13 WL41 VDD VSS bitcell_6t
Xr41c14 BL14 BLB14 WL41 VDD VSS bitcell_6t
Xr41c15 BL15 BLB15 WL41 VDD VSS bitcell_6t
Xr41c16 BL16 BLB16 WL41 VDD VSS bitcell_6t
Xr41c17 BL17 BLB17 WL41 VDD VSS bitcell_6t
Xr41c18 BL18 BLB18 WL41 VDD VSS bitcell_6t
Xr41c19 BL19 BLB19 WL41 VDD VSS bitcell_6t
Xr41c20 BL20 BLB20 WL41 VDD VSS bitcell_6t
Xr41c21 BL21 BLB21 WL41 VDD VSS bitcell_6t
Xr41c22 BL22 BLB22 WL41 VDD VSS bitcell_6t
Xr41c23 BL23 BLB23 WL41 VDD VSS bitcell_6t
Xr41c24 BL24 BLB24 WL41 VDD VSS bitcell_6t
Xr41c25 BL25 BLB25 WL41 VDD VSS bitcell_6t
Xr41c26 BL26 BLB26 WL41 VDD VSS bitcell_6t
Xr41c27 BL27 BLB27 WL41 VDD VSS bitcell_6t
Xr41c28 BL28 BLB28 WL41 VDD VSS bitcell_6t
Xr41c29 BL29 BLB29 WL41 VDD VSS bitcell_6t
Xr41c30 BL30 BLB30 WL41 VDD VSS bitcell_6t
Xr41c31 BL31 BLB31 WL41 VDD VSS bitcell_6t
Xr41c32 BL32 BLB32 WL41 VDD VSS bitcell_6t
Xr41c33 BL33 BLB33 WL41 VDD VSS bitcell_6t
Xr41c34 BL34 BLB34 WL41 VDD VSS bitcell_6t
Xr41c35 BL35 BLB35 WL41 VDD VSS bitcell_6t
Xr41c36 BL36 BLB36 WL41 VDD VSS bitcell_6t
Xr41c37 BL37 BLB37 WL41 VDD VSS bitcell_6t
Xr41c38 BL38 BLB38 WL41 VDD VSS bitcell_6t
Xr41c39 BL39 BLB39 WL41 VDD VSS bitcell_6t
Xr41c40 BL40 BLB40 WL41 VDD VSS bitcell_6t
Xr41c41 BL41 BLB41 WL41 VDD VSS bitcell_6t
Xr41c42 BL42 BLB42 WL41 VDD VSS bitcell_6t
Xr41c43 BL43 BLB43 WL41 VDD VSS bitcell_6t
Xr41c44 BL44 BLB44 WL41 VDD VSS bitcell_6t
Xr41c45 BL45 BLB45 WL41 VDD VSS bitcell_6t
Xr41c46 BL46 BLB46 WL41 VDD VSS bitcell_6t
Xr41c47 BL47 BLB47 WL41 VDD VSS bitcell_6t
Xr41c48 BL48 BLB48 WL41 VDD VSS bitcell_6t
Xr41c49 BL49 BLB49 WL41 VDD VSS bitcell_6t
Xr41c50 BL50 BLB50 WL41 VDD VSS bitcell_6t
Xr41c51 BL51 BLB51 WL41 VDD VSS bitcell_6t
Xr41c52 BL52 BLB52 WL41 VDD VSS bitcell_6t
Xr41c53 BL53 BLB53 WL41 VDD VSS bitcell_6t
Xr41c54 BL54 BLB54 WL41 VDD VSS bitcell_6t
Xr41c55 BL55 BLB55 WL41 VDD VSS bitcell_6t
Xr41c56 BL56 BLB56 WL41 VDD VSS bitcell_6t
Xr41c57 BL57 BLB57 WL41 VDD VSS bitcell_6t
Xr41c58 BL58 BLB58 WL41 VDD VSS bitcell_6t
Xr41c59 BL59 BLB59 WL41 VDD VSS bitcell_6t
Xr41c60 BL60 BLB60 WL41 VDD VSS bitcell_6t
Xr41c61 BL61 BLB61 WL41 VDD VSS bitcell_6t
Xr41c62 BL62 BLB62 WL41 VDD VSS bitcell_6t
Xr41c63 BL63 BLB63 WL41 VDD VSS bitcell_6t
Xr41c64 BL64 BLB64 WL41 VDD VSS bitcell_6t
Xr41c65 BL65 BLB65 WL41 VDD VSS bitcell_6t
Xr41c66 BL66 BLB66 WL41 VDD VSS bitcell_6t
Xr41c67 BL67 BLB67 WL41 VDD VSS bitcell_6t
Xr41c68 BL68 BLB68 WL41 VDD VSS bitcell_6t
Xr41c69 BL69 BLB69 WL41 VDD VSS bitcell_6t
Xr41c70 BL70 BLB70 WL41 VDD VSS bitcell_6t
Xr41c71 BL71 BLB71 WL41 VDD VSS bitcell_6t
Xr41c72 BL72 BLB72 WL41 VDD VSS bitcell_6t
Xr41c73 BL73 BLB73 WL41 VDD VSS bitcell_6t
Xr41c74 BL74 BLB74 WL41 VDD VSS bitcell_6t
Xr41c75 BL75 BLB75 WL41 VDD VSS bitcell_6t
Xr41c76 BL76 BLB76 WL41 VDD VSS bitcell_6t
Xr41c77 BL77 BLB77 WL41 VDD VSS bitcell_6t
Xr41c78 BL78 BLB78 WL41 VDD VSS bitcell_6t
Xr41c79 BL79 BLB79 WL41 VDD VSS bitcell_6t
Xr41c80 BL80 BLB80 WL41 VDD VSS bitcell_6t
Xr41c81 BL81 BLB81 WL41 VDD VSS bitcell_6t
Xr41c82 BL82 BLB82 WL41 VDD VSS bitcell_6t
Xr41c83 BL83 BLB83 WL41 VDD VSS bitcell_6t
Xr41c84 BL84 BLB84 WL41 VDD VSS bitcell_6t
Xr41c85 BL85 BLB85 WL41 VDD VSS bitcell_6t
Xr41c86 BL86 BLB86 WL41 VDD VSS bitcell_6t
Xr41c87 BL87 BLB87 WL41 VDD VSS bitcell_6t
Xr41c88 BL88 BLB88 WL41 VDD VSS bitcell_6t
Xr41c89 BL89 BLB89 WL41 VDD VSS bitcell_6t
Xr41c90 BL90 BLB90 WL41 VDD VSS bitcell_6t
Xr41c91 BL91 BLB91 WL41 VDD VSS bitcell_6t
Xr41c92 BL92 BLB92 WL41 VDD VSS bitcell_6t
Xr41c93 BL93 BLB93 WL41 VDD VSS bitcell_6t
Xr41c94 BL94 BLB94 WL41 VDD VSS bitcell_6t
Xr41c95 BL95 BLB95 WL41 VDD VSS bitcell_6t
Xr41c96 BL96 BLB96 WL41 VDD VSS bitcell_6t
Xr41c97 BL97 BLB97 WL41 VDD VSS bitcell_6t
Xr41c98 BL98 BLB98 WL41 VDD VSS bitcell_6t
Xr41c99 BL99 BLB99 WL41 VDD VSS bitcell_6t
Xr41c100 BL100 BLB100 WL41 VDD VSS bitcell_6t
Xr41c101 BL101 BLB101 WL41 VDD VSS bitcell_6t
Xr41c102 BL102 BLB102 WL41 VDD VSS bitcell_6t
Xr41c103 BL103 BLB103 WL41 VDD VSS bitcell_6t
Xr41c104 BL104 BLB104 WL41 VDD VSS bitcell_6t
Xr41c105 BL105 BLB105 WL41 VDD VSS bitcell_6t
Xr41c106 BL106 BLB106 WL41 VDD VSS bitcell_6t
Xr41c107 BL107 BLB107 WL41 VDD VSS bitcell_6t
Xr41c108 BL108 BLB108 WL41 VDD VSS bitcell_6t
Xr41c109 BL109 BLB109 WL41 VDD VSS bitcell_6t
Xr41c110 BL110 BLB110 WL41 VDD VSS bitcell_6t
Xr41c111 BL111 BLB111 WL41 VDD VSS bitcell_6t
Xr41c112 BL112 BLB112 WL41 VDD VSS bitcell_6t
Xr41c113 BL113 BLB113 WL41 VDD VSS bitcell_6t
Xr41c114 BL114 BLB114 WL41 VDD VSS bitcell_6t
Xr41c115 BL115 BLB115 WL41 VDD VSS bitcell_6t
Xr41c116 BL116 BLB116 WL41 VDD VSS bitcell_6t
Xr41c117 BL117 BLB117 WL41 VDD VSS bitcell_6t
Xr41c118 BL118 BLB118 WL41 VDD VSS bitcell_6t
Xr41c119 BL119 BLB119 WL41 VDD VSS bitcell_6t
Xr41c120 BL120 BLB120 WL41 VDD VSS bitcell_6t
Xr41c121 BL121 BLB121 WL41 VDD VSS bitcell_6t
Xr41c122 BL122 BLB122 WL41 VDD VSS bitcell_6t
Xr41c123 BL123 BLB123 WL41 VDD VSS bitcell_6t
Xr41c124 BL124 BLB124 WL41 VDD VSS bitcell_6t
Xr41c125 BL125 BLB125 WL41 VDD VSS bitcell_6t
Xr41c126 BL126 BLB126 WL41 VDD VSS bitcell_6t
Xr41c127 BL127 BLB127 WL41 VDD VSS bitcell_6t
Cbl0 BL0 VSS 20f
Cblb0 BLB0 VSS 20f
Cbl1 BL1 VSS 20f
Cblb1 BLB1 VSS 20f
Cbl2 BL2 VSS 20f
Cblb2 BLB2 VSS 20f
Cbl3 BL3 VSS 20f
Cblb3 BLB3 VSS 20f
Cbl4 BL4 VSS 20f
Cblb4 BLB4 VSS 20f
Cbl5 BL5 VSS 20f
Cblb5 BLB5 VSS 20f
Cbl6 BL6 VSS 20f
Cblb6 BLB6 VSS 20f
Cbl7 BL7 VSS 20f
Cblb7 BLB7 VSS 20f
Cbl8 BL8 VSS 20f
Cblb8 BLB8 VSS 20f
Cbl9 BL9 VSS 20f
Cblb9 BLB9 VSS 20f
Cbl10 BL10 VSS 20f
Cblb10 BLB10 VSS 20f
Cbl11 BL11 VSS 20f
Cblb11 BLB11 VSS 20f
Cbl12 BL12 VSS 20f
Cblb12 BLB12 VSS 20f
Cbl13 BL13 VSS 20f
Cblb13 BLB13 VSS 20f
Cbl14 BL14 VSS 20f
Cblb14 BLB14 VSS 20f
Cbl15 BL15 VSS 20f
Cblb15 BLB15 VSS 20f
Cbl16 BL16 VSS 20f
Cblb16 BLB16 VSS 20f
Cbl17 BL17 VSS 20f
Cblb17 BLB17 VSS 20f
Cbl18 BL18 VSS 20f
Cblb18 BLB18 VSS 20f
Cbl19 BL19 VSS 20f
Cblb19 BLB19 VSS 20f
Cbl20 BL20 VSS 20f
Cblb20 BLB20 VSS 20f
Cbl21 BL21 VSS 20f
Cblb21 BLB21 VSS 20f
Cbl22 BL22 VSS 20f
Cblb22 BLB22 VSS 20f
Cbl23 BL23 VSS 20f
Cblb23 BLB23 VSS 20f
Cbl24 BL24 VSS 20f
Cblb24 BLB24 VSS 20f
Cbl25 BL25 VSS 20f
Cblb25 BLB25 VSS 20f
Cbl26 BL26 VSS 20f
Cblb26 BLB26 VSS 20f
Cbl27 BL27 VSS 20f
Cblb27 BLB27 VSS 20f
Cbl28 BL28 VSS 20f
Cblb28 BLB28 VSS 20f
Cbl29 BL29 VSS 20f
Cblb29 BLB29 VSS 20f
Cbl30 BL30 VSS 20f
Cblb30 BLB30 VSS 20f
Cbl31 BL31 VSS 20f
Cblb31 BLB31 VSS 20f
Cbl32 BL32 VSS 20f
Cblb32 BLB32 VSS 20f
Cbl33 BL33 VSS 20f
Cblb33 BLB33 VSS 20f
Cbl34 BL34 VSS 20f
Cblb34 BLB34 VSS 20f
Cbl35 BL35 VSS 20f
Cblb35 BLB35 VSS 20f
Cbl36 BL36 VSS 20f
Cblb36 BLB36 VSS 20f
Cbl37 BL37 VSS 20f
Cblb37 BLB37 VSS 20f
Cbl38 BL38 VSS 20f
Cblb38 BLB38 VSS 20f
Cbl39 BL39 VSS 20f
Cblb39 BLB39 VSS 20f
Cbl40 BL40 VSS 20f
Cblb40 BLB40 VSS 20f
Cbl41 BL41 VSS 20f
Cblb41 BLB41 VSS 20f
Cbl42 BL42 VSS 20f
Cblb42 BLB42 VSS 20f
Cbl43 BL43 VSS 20f
Cblb43 BLB43 VSS 20f
Cbl44 BL44 VSS 20f
Cblb44 BLB44 VSS 20f
Cbl45 BL45 VSS 20f
Cblb45 BLB45 VSS 20f
Cbl46 BL46 VSS 20f
Cblb46 BLB46 VSS 20f
Cbl47 BL47 VSS 20f
Cblb47 BLB47 VSS 20f
Cbl48 BL48 VSS 20f
Cblb48 BLB48 VSS 20f
Cbl49 BL49 VSS 20f
Cblb49 BLB49 VSS 20f
Cbl50 BL50 VSS 20f
Cblb50 BLB50 VSS 20f
Cbl51 BL51 VSS 20f
Cblb51 BLB51 VSS 20f
Cbl52 BL52 VSS 20f
Cblb52 BLB52 VSS 20f
Cbl53 BL53 VSS 20f
Cblb53 BLB53 VSS 20f
Cbl54 BL54 VSS 20f
Cblb54 BLB54 VSS 20f
Cbl55 BL55 VSS 20f
Cblb55 BLB55 VSS 20f
Cbl56 BL56 VSS 20f
Cblb56 BLB56 VSS 20f
Cbl57 BL57 VSS 20f
Cblb57 BLB57 VSS 20f
Cbl58 BL58 VSS 20f
Cblb58 BLB58 VSS 20f
Cbl59 BL59 VSS 20f
Cblb59 BLB59 VSS 20f
Cbl60 BL60 VSS 20f
Cblb60 BLB60 VSS 20f
Cbl61 BL61 VSS 20f
Cblb61 BLB61 VSS 20f
Cbl62 BL62 VSS 20f
Cblb62 BLB62 VSS 20f
Cbl63 BL63 VSS 20f
Cblb63 BLB63 VSS 20f
Cbl64 BL64 VSS 20f
Cblb64 BLB64 VSS 20f
Cbl65 BL65 VSS 20f
Cblb65 BLB65 VSS 20f
Cbl66 BL66 VSS 20f
Cblb66 BLB66 VSS 20f
Cbl67 BL67 VSS 20f
Cblb67 BLB67 VSS 20f
Cbl68 BL68 VSS 20f
Cblb68 BLB68 VSS 20f
Cbl69 BL69 VSS 20f
Cblb69 BLB69 VSS 20f
Cbl70 BL70 VSS 20f
Cblb70 BLB70 VSS 20f
Cbl71 BL71 VSS 20f
Cblb71 BLB71 VSS 20f
Cbl72 BL72 VSS 20f
Cblb72 BLB72 VSS 20f
Cbl73 BL73 VSS 20f
Cblb73 BLB73 VSS 20f
Cbl74 BL74 VSS 20f
Cblb74 BLB74 VSS 20f
Cbl75 BL75 VSS 20f
Cblb75 BLB75 VSS 20f
Cbl76 BL76 VSS 20f
Cblb76 BLB76 VSS 20f
Cbl77 BL77 VSS 20f
Cblb77 BLB77 VSS 20f
Cbl78 BL78 VSS 20f
Cblb78 BLB78 VSS 20f
Cbl79 BL79 VSS 20f
Cblb79 BLB79 VSS 20f
Cbl80 BL80 VSS 20f
Cblb80 BLB80 VSS 20f
Cbl81 BL81 VSS 20f
Cblb81 BLB81 VSS 20f
Cbl82 BL82 VSS 20f
Cblb82 BLB82 VSS 20f
Cbl83 BL83 VSS 20f
Cblb83 BLB83 VSS 20f
Cbl84 BL84 VSS 20f
Cblb84 BLB84 VSS 20f
Cbl85 BL85 VSS 20f
Cblb85 BLB85 VSS 20f
Cbl86 BL86 VSS 20f
Cblb86 BLB86 VSS 20f
Cbl87 BL87 VSS 20f
Cblb87 BLB87 VSS 20f
Cbl88 BL88 VSS 20f
Cblb88 BLB88 VSS 20f
Cbl89 BL89 VSS 20f
Cblb89 BLB89 VSS 20f
Cbl90 BL90 VSS 20f
Cblb90 BLB90 VSS 20f
Cbl91 BL91 VSS 20f
Cblb91 BLB91 VSS 20f
Cbl92 BL92 VSS 20f
Cblb92 BLB92 VSS 20f
Cbl93 BL93 VSS 20f
Cblb93 BLB93 VSS 20f
Cbl94 BL94 VSS 20f
Cblb94 BLB94 VSS 20f
Cbl95 BL95 VSS 20f
Cblb95 BLB95 VSS 20f
Cbl96 BL96 VSS 20f
Cblb96 BLB96 VSS 20f
Cbl97 BL97 VSS 20f
Cblb97 BLB97 VSS 20f
Cbl98 BL98 VSS 20f
Cblb98 BLB98 VSS 20f
Cbl99 BL99 VSS 20f
Cblb99 BLB99 VSS 20f
Cbl100 BL100 VSS 20f
Cblb100 BLB100 VSS 20f
Cbl101 BL101 VSS 20f
Cblb101 BLB101 VSS 20f
Cbl102 BL102 VSS 20f
Cblb102 BLB102 VSS 20f
Cbl103 BL103 VSS 20f
Cblb103 BLB103 VSS 20f
Cbl104 BL104 VSS 20f
Cblb104 BLB104 VSS 20f
Cbl105 BL105 VSS 20f
Cblb105 BLB105 VSS 20f
Cbl106 BL106 VSS 20f
Cblb106 BLB106 VSS 20f
Cbl107 BL107 VSS 20f
Cblb107 BLB107 VSS 20f
Cbl108 BL108 VSS 20f
Cblb108 BLB108 VSS 20f
Cbl109 BL109 VSS 20f
Cblb109 BLB109 VSS 20f
Cbl110 BL110 VSS 20f
Cblb110 BLB110 VSS 20f
Cbl111 BL111 VSS 20f
Cblb111 BLB111 VSS 20f
Cbl112 BL112 VSS 20f
Cblb112 BLB112 VSS 20f
Cbl113 BL113 VSS 20f
Cblb113 BLB113 VSS 20f
Cbl114 BL114 VSS 20f
Cblb114 BLB114 VSS 20f
Cbl115 BL115 VSS 20f
Cblb115 BLB115 VSS 20f
Cbl116 BL116 VSS 20f
Cblb116 BLB116 VSS 20f
Cbl117 BL117 VSS 20f
Cblb117 BLB117 VSS 20f
Cbl118 BL118 VSS 20f
Cblb118 BLB118 VSS 20f
Cbl119 BL119 VSS 20f
Cblb119 BLB119 VSS 20f
Cbl120 BL120 VSS 20f
Cblb120 BLB120 VSS 20f
Cbl121 BL121 VSS 20f
Cblb121 BLB121 VSS 20f
Cbl122 BL122 VSS 20f
Cblb122 BLB122 VSS 20f
Cbl123 BL123 VSS 20f
Cblb123 BLB123 VSS 20f
Cbl124 BL124 VSS 20f
Cblb124 BLB124 VSS 20f
Cbl125 BL125 VSS 20f
Cblb125 BLB125 VSS 20f
Cbl126 BL126 VSS 20f
Cblb126 BLB126 VSS 20f
Cbl127 BL127 VSS 20f
Cblb127 BLB127 VSS 20f
.ends

VCLK CLK 0 PWL(0 0 5n 0 5.1n VDDC 15n VDDC 15.1n 0 25n 0 25.1n VDDC 35n VDDC 35.1n 0 45n 0 45.1n VDDC 55n VDDC 55.1n 0 65n 0 65.1n VDDC 75n VDDC 75.1n 0 85n 0 85.1n VDDC 95n VDDC 95.1n 0 105n 0 105.1n VDDC 115n VDDC 115.1n 0 125n 0 125.1n VDDC 135n VDDC 135.1n 0 145n 0 145.1n VDDC 155n VDDC 155.1n 0 165n 0 165.1n VDDC 175n VDDC 175.1n 0 185n 0 185.1n VDDC 195n VDDC 195.1n 0)
VCEN CEN 0 PWL(0 VDDC 19n VDDC 19.1n 0 159n 0 159.1n VDDC 179n VDDC 179.1n 0)
VGWEN GWEN 0 PWL(0 VDDC 19n VDDC 19.1n 0 59n 0 59.1n VDDC 99n VDDC 99.1n 0 119n 0 119.1n VDDC 159n VDDC 159.1n 0 179n 0 179.1n VDDC)
VA0 A0_s 0 PWL(0 0 19n 0 19.1n VDDC 39n VDDC 39.1n 0 59n 0 59.1n VDDC 79n VDDC 79.1n 0 99n 0 99.1n VDDC 139n VDDC 139.1n 0 159n 0 159.1n VDDC)
VA1 A1_s 0 PWL(0 0 19n 0 19.1n VDDC 39n VDDC 39.1n 0 59n 0 59.1n VDDC 79n VDDC 79.1n 0 99n 0 99.1n VDDC 139n VDDC 139.1n 0 159n 0 159.1n VDDC)
VA2 A2_s 0 PWL(0 0 19n 0 19.1n VDDC)
VA3 A3_s 0 PWL(0 0 39n 0 39.1n VDDC 59n VDDC 59.1n 0 79n 0 79.1n VDDC 99n VDDC 99.1n 0 139n 0 139.1n VDDC 159n VDDC 159.1n 0)
VA4 A4_s 0 PWL(0 0 39n 0 39.1n VDDC 59n VDDC 59.1n 0 79n 0 79.1n VDDC 99n VDDC 99.1n 0 139n 0 139.1n VDDC 159n VDDC 159.1n 0)
VA5 A5_s 0 PWL(0 0 19n 0 19.1n VDDC)
VA6 A6_s 0 PWL(0 0)
VA7 A7_s 0 PWL(0 0 19n 0 19.1n VDDC 39n VDDC 39.1n 0 59n 0 59.1n VDDC 79n VDDC 79.1n 0 99n 0 99.1n VDDC 139n VDDC 139.1n 0 159n 0 159.1n VDDC)
VD0 D0_s 0 PWL(0 0 19n 0 19.1n VDDC 39n VDDC 39.1n 0 99n 0 99.1n VDDC 119n VDDC 119.1n 0)
VW0 WEN0_s 0 PWL(0 VDDC 19n VDDC 19.1n 0 59n 0 59.1n VDDC 159n VDDC 159.1n 0 179n 0 179.1n VDDC)
VD1 D1_s 0 PWL(0 0 19n 0 19.1n VDDC 39n VDDC 39.1n 0 99n 0 99.1n VDDC 119n VDDC 119.1n 0)
VW1 WEN1_s 0 PWL(0 VDDC 19n VDDC 19.1n 0 59n 0 59.1n VDDC 159n VDDC 159.1n 0 179n 0 179.1n VDDC)
VD2 D2_s 0 PWL(0 0 19n 0 19.1n VDDC 39n VDDC 39.1n 0 99n 0 99.1n VDDC 119n VDDC 119.1n 0)
VW2 WEN2_s 0 PWL(0 VDDC 19n VDDC 19.1n 0 59n 0 59.1n VDDC 159n VDDC 159.1n 0 179n 0 179.1n VDDC)
VD3 D3_s 0 PWL(0 0 19n 0 19.1n VDDC 59n VDDC 59.1n 0 99n 0 99.1n VDDC 119n VDDC 119.1n 0)
VW3 WEN3_s 0 PWL(0 VDDC 19n VDDC 19.1n 0 59n 0 59.1n VDDC 159n VDDC 159.1n 0 179n 0 179.1n VDDC)
VD4 D4_s 0 PWL(0 0 39n 0 39.1n VDDC 59n VDDC 59.1n 0 99n 0 99.1n VDDC 119n VDDC 119.1n 0)
VW4 WEN4_s 0 PWL(0 VDDC 19n VDDC 19.1n 0 59n 0 59.1n VDDC 159n VDDC 159.1n 0 179n 0 179.1n VDDC)
VD5 D5_s 0 PWL(0 0 19n 0 19.1n VDDC 59n VDDC 59.1n 0 99n 0 99.1n VDDC 119n VDDC 119.1n 0)
VW5 WEN5_s 0 PWL(0 VDDC 19n VDDC 19.1n 0 59n 0 59.1n VDDC 159n VDDC 159.1n 0 179n 0 179.1n VDDC)
VD6 D6_s 0 PWL(0 0 19n 0 19.1n VDDC 59n VDDC 59.1n 0 99n 0 99.1n VDDC 119n VDDC 119.1n 0)
VW6 WEN6_s 0 PWL(0 VDDC 19n VDDC 19.1n 0 59n 0 59.1n VDDC 159n VDDC 159.1n 0 179n 0 179.1n VDDC)
VD7 D7_s 0 PWL(0 0 19n 0 19.1n VDDC 39n VDDC 39.1n 0 99n 0 99.1n VDDC 119n VDDC 119.1n 0)
VW7 WEN7_s 0 PWL(0 VDDC 19n VDDC 19.1n 0 59n 0 59.1n VDDC 159n VDDC 159.1n 0 179n 0 179.1n VDDC)
VD8 D8_s 0 PWL(0 0 99n 0 99.1n VDDC 119n VDDC 119.1n 0)
VW8 WEN8_s 0 PWL(0 VDDC 19n VDDC 19.1n 0 59n 0 59.1n VDDC 159n VDDC 159.1n 0 179n 0 179.1n VDDC)
VD9 D9_s 0 PWL(0 0 19n 0 19.1n VDDC 59n VDDC 59.1n 0 99n 0 99.1n VDDC 119n VDDC 119.1n 0)
VW9 WEN9_s 0 PWL(0 VDDC 19n VDDC 19.1n 0 59n 0 59.1n VDDC 159n VDDC 159.1n 0 179n 0 179.1n VDDC)
VD10 D10_s 0 PWL(0 0 19n 0 19.1n VDDC 59n VDDC 59.1n 0 99n 0 99.1n VDDC 119n VDDC 119.1n 0)
VW10 WEN10_s 0 PWL(0 VDDC 19n VDDC 19.1n 0 59n 0 59.1n VDDC 159n VDDC 159.1n 0 179n 0 179.1n VDDC)
VD11 D11_s 0 PWL(0 0 19n 0 19.1n VDDC 39n VDDC 39.1n 0 99n 0 99.1n VDDC 119n VDDC 119.1n 0)
VW11 WEN11_s 0 PWL(0 VDDC 19n VDDC 19.1n 0 59n 0 59.1n VDDC 159n VDDC 159.1n 0 179n 0 179.1n VDDC)
VD12 D12_s 0 PWL(0 0 19n 0 19.1n VDDC 59n VDDC 59.1n 0 99n 0 99.1n VDDC 119n VDDC 119.1n 0)
VW12 WEN12_s 0 PWL(0 VDDC 19n VDDC 19.1n 0 59n 0 59.1n VDDC 159n VDDC 159.1n 0 179n 0 179.1n VDDC)
VD13 D13_s 0 PWL(0 0 19n 0 19.1n VDDC 39n VDDC 39.1n 0 99n 0 99.1n VDDC 119n VDDC 119.1n 0)
VW13 WEN13_s 0 PWL(0 VDDC 19n VDDC 19.1n 0 59n 0 59.1n VDDC 159n VDDC 159.1n 0 179n 0 179.1n VDDC)
VD14 D14_s 0 PWL(0 0 39n 0 39.1n VDDC 59n VDDC 59.1n 0 99n 0 99.1n VDDC 119n VDDC 119.1n 0)
VW14 WEN14_s 0 PWL(0 VDDC 19n VDDC 19.1n 0 59n 0 59.1n VDDC 159n VDDC 159.1n 0 179n 0 179.1n VDDC)
VD15 D15_s 0 PWL(0 0 19n 0 19.1n VDDC 39n VDDC 39.1n 0 99n 0 99.1n VDDC 119n VDDC 119.1n 0)
VW15 WEN15_s 0 PWL(0 VDDC 19n VDDC 19.1n 0 59n 0 59.1n VDDC 159n VDDC 159.1n 0 179n 0 179.1n VDDC)
VD16 D16_s 0 PWL(0 0 19n 0 19.1n VDDC 39n VDDC 39.1n 0 99n 0 99.1n VDDC 119n VDDC 119.1n 0)
VW16 WEN16_s 0 PWL(0 VDDC 19n VDDC 19.1n 0 59n 0 59.1n VDDC 99n VDDC 99.1n 0 119n 0 119.1n VDDC 159n VDDC 159.1n 0 179n 0 179.1n VDDC)
VD17 D17_s 0 PWL(0 0 99n 0 99.1n VDDC 119n VDDC 119.1n 0)
VW17 WEN17_s 0 PWL(0 VDDC 19n VDDC 19.1n 0 59n 0 59.1n VDDC 99n VDDC 99.1n 0 119n 0 119.1n VDDC 159n VDDC 159.1n 0 179n 0 179.1n VDDC)
VD18 D18_s 0 PWL(0 0 19n 0 19.1n VDDC 59n VDDC 59.1n 0 99n 0 99.1n VDDC 119n VDDC 119.1n 0)
VW18 WEN18_s 0 PWL(0 VDDC 19n VDDC 19.1n 0 59n 0 59.1n VDDC 99n VDDC 99.1n 0 119n 0 119.1n VDDC 159n VDDC 159.1n 0 179n 0 179.1n VDDC)
VD19 D19_s 0 PWL(0 0 19n 0 19.1n VDDC 39n VDDC 39.1n 0 99n 0 99.1n VDDC 119n VDDC 119.1n 0)
VW19 WEN19_s 0 PWL(0 VDDC 19n VDDC 19.1n 0 59n 0 59.1n VDDC 99n VDDC 99.1n 0 119n 0 119.1n VDDC 159n VDDC 159.1n 0 179n 0 179.1n VDDC)
VD20 D20_s 0 PWL(0 0 39n 0 39.1n VDDC 59n VDDC 59.1n 0 99n 0 99.1n VDDC 119n VDDC 119.1n 0)
VW20 WEN20_s 0 PWL(0 VDDC 19n VDDC 19.1n 0 59n 0 59.1n VDDC 99n VDDC 99.1n 0 119n 0 119.1n VDDC 159n VDDC 159.1n 0 179n 0 179.1n VDDC)
VD21 D21_s 0 PWL(0 0 19n 0 19.1n VDDC 59n VDDC 59.1n 0 99n 0 99.1n VDDC 119n VDDC 119.1n 0)
VW21 WEN21_s 0 PWL(0 VDDC 19n VDDC 19.1n 0 59n 0 59.1n VDDC 99n VDDC 99.1n 0 119n 0 119.1n VDDC 159n VDDC 159.1n 0 179n 0 179.1n VDDC)
VD22 D22_s 0 PWL(0 0 99n 0 99.1n VDDC 119n VDDC 119.1n 0)
VW22 WEN22_s 0 PWL(0 VDDC 19n VDDC 19.1n 0 59n 0 59.1n VDDC 99n VDDC 99.1n 0 119n 0 119.1n VDDC 159n VDDC 159.1n 0 179n 0 179.1n VDDC)
VD23 D23_s 0 PWL(0 0 19n 0 19.1n VDDC 39n VDDC 39.1n 0 99n 0 99.1n VDDC 119n VDDC 119.1n 0)
VW23 WEN23_s 0 PWL(0 VDDC 19n VDDC 19.1n 0 59n 0 59.1n VDDC 99n VDDC 99.1n 0 119n 0 119.1n VDDC 159n VDDC 159.1n 0 179n 0 179.1n VDDC)
VD24 D24_s 0 PWL(0 0 99n 0 99.1n VDDC 119n VDDC 119.1n 0)
VW24 WEN24_s 0 PWL(0 VDDC 19n VDDC 19.1n 0 59n 0 59.1n VDDC 99n VDDC 99.1n 0 119n 0 119.1n VDDC 159n VDDC 159.1n 0 179n 0 179.1n VDDC)
VD25 D25_s 0 PWL(0 0 19n 0 19.1n VDDC 59n VDDC 59.1n 0 99n 0 99.1n VDDC 119n VDDC 119.1n 0)
VW25 WEN25_s 0 PWL(0 VDDC 19n VDDC 19.1n 0 59n 0 59.1n VDDC 99n VDDC 99.1n 0 119n 0 119.1n VDDC 159n VDDC 159.1n 0 179n 0 179.1n VDDC)
VD26 D26_s 0 PWL(0 0 19n 0 19.1n VDDC 39n VDDC 39.1n 0 99n 0 99.1n VDDC 119n VDDC 119.1n 0)
VW26 WEN26_s 0 PWL(0 VDDC 19n VDDC 19.1n 0 59n 0 59.1n VDDC 99n VDDC 99.1n 0 119n 0 119.1n VDDC 159n VDDC 159.1n 0 179n 0 179.1n VDDC)
VD27 D27_s 0 PWL(0 0 19n 0 19.1n VDDC 39n VDDC 39.1n 0 99n 0 99.1n VDDC 119n VDDC 119.1n 0)
VW27 WEN27_s 0 PWL(0 VDDC 19n VDDC 19.1n 0 59n 0 59.1n VDDC 99n VDDC 99.1n 0 119n 0 119.1n VDDC 159n VDDC 159.1n 0 179n 0 179.1n VDDC)
VD28 D28_s 0 PWL(0 0 19n 0 19.1n VDDC 59n VDDC 59.1n 0 99n 0 99.1n VDDC 119n VDDC 119.1n 0)
VW28 WEN28_s 0 PWL(0 VDDC 19n VDDC 19.1n 0 59n 0 59.1n VDDC 99n VDDC 99.1n 0 119n 0 119.1n VDDC 159n VDDC 159.1n 0 179n 0 179.1n VDDC)
VD29 D29_s 0 PWL(0 0 99n 0 99.1n VDDC 119n VDDC 119.1n 0)
VW29 WEN29_s 0 PWL(0 VDDC 19n VDDC 19.1n 0 59n 0 59.1n VDDC 99n VDDC 99.1n 0 119n 0 119.1n VDDC 159n VDDC 159.1n 0 179n 0 179.1n VDDC)
VD30 D30_s 0 PWL(0 0 19n 0 19.1n VDDC 39n VDDC 39.1n 0 99n 0 99.1n VDDC 119n VDDC 119.1n 0)
VW30 WEN30_s 0 PWL(0 VDDC 19n VDDC 19.1n 0 59n 0 59.1n VDDC 99n VDDC 99.1n 0 119n 0 119.1n VDDC 159n VDDC 159.1n 0 179n 0 179.1n VDDC)
VD31 D31_s 0 PWL(0 0 19n 0 19.1n VDDC 39n VDDC 39.1n 0 99n 0 99.1n VDDC 119n VDDC 119.1n 0)
VW31 WEN31_s 0 PWL(0 VDDC 19n VDDC 19.1n 0 59n 0 59.1n VDDC 99n VDDC 99.1n 0 119n 0 119.1n VDDC 159n VDDC 159.1n 0 179n 0 179.1n VDDC)
RA0 A0_s A[0] 1
RA1 A1_s A[1] 1
RA2 A2_s A[2] 1
RA3 A3_s A[3] 1
RA4 A4_s A[4] 1
RA5 A5_s A[5] 1
RA6 A6_s A[6] 1
RA7 A7_s A[7] 1
RD0 D0_s D[0] 1
RW0 WEN0_s WEN[0] 1
RD1 D1_s D[1] 1
RW1 WEN1_s WEN[1] 1
RD2 D2_s D[2] 1
RW2 WEN2_s WEN[2] 1
RD3 D3_s D[3] 1
RW3 WEN3_s WEN[3] 1
RD4 D4_s D[4] 1
RW4 WEN4_s WEN[4] 1
RD5 D5_s D[5] 1
RW5 WEN5_s WEN[5] 1
RD6 D6_s D[6] 1
RW6 WEN6_s WEN[6] 1
RD7 D7_s D[7] 1
RW7 WEN7_s WEN[7] 1
RD8 D8_s D[8] 1
RW8 WEN8_s WEN[8] 1
RD9 D9_s D[9] 1
RW9 WEN9_s WEN[9] 1
RD10 D10_s D[10] 1
RW10 WEN10_s WEN[10] 1
RD11 D11_s D[11] 1
RW11 WEN11_s WEN[11] 1
RD12 D12_s D[12] 1
RW12 WEN12_s WEN[12] 1
RD13 D13_s D[13] 1
RW13 WEN13_s WEN[13] 1
RD14 D14_s D[14] 1
RW14 WEN14_s WEN[14] 1
RD15 D15_s D[15] 1
RW15 WEN15_s WEN[15] 1
RD16 D16_s D[16] 1
RW16 WEN16_s WEN[16] 1
RD17 D17_s D[17] 1
RW17 WEN17_s WEN[17] 1
RD18 D18_s D[18] 1
RW18 WEN18_s WEN[18] 1
RD19 D19_s D[19] 1
RW19 WEN19_s WEN[19] 1
RD20 D20_s D[20] 1
RW20 WEN20_s WEN[20] 1
RD21 D21_s D[21] 1
RW21 WEN21_s WEN[21] 1
RD22 D22_s D[22] 1
RW22 WEN22_s WEN[22] 1
RD23 D23_s D[23] 1
RW23 WEN23_s WEN[23] 1
RD24 D24_s D[24] 1
RW24 WEN24_s WEN[24] 1
RD25 D25_s D[25] 1
RW25 WEN25_s WEN[25] 1
RD26 D26_s D[26] 1
RW26 WEN26_s WEN[26] 1
RD27 D27_s D[27] 1
RW27 WEN27_s WEN[27] 1
RD28 D28_s D[28] 1
RW28 WEN28_s WEN[28] 1
RD29 D29_s D[29] 1
RW29 WEN29_s WEN[29] 1
RD30 D30_s D[30] 1
RW30 WEN30_s WEN[30] 1
RD31 D31_s D[31] 1
RW31 WEN31_s WEN[31] 1
XDUT A[7] A[6] A[5] A[4] A[3] A[2] A[1] A[0] CEN GWEN CLK D[31] D[30] D[29] D[28] D[27] D[26] D[25] D[24] D[23] D[22] D[21] D[20] D[19] D[18] D[17] D[16] D[15] D[14] D[13] D[12] D[11] D[10] D[9] D[8] D[7] D[6] D[5] D[4] D[3] D[2] D[1] D[0] WEN[31] WEN[30] WEN[29] WEN[28] WEN[27] WEN[26] WEN[25] WEN[24] WEN[23] WEN[22] WEN[21] WEN[20] WEN[19] WEN[18] WEN[17] WEN[16] WEN[15] WEN[14] WEN[13] WEN[12] WEN[11] WEN[10] WEN[9] WEN[8] WEN[7] WEN[6] WEN[5] WEN[4] WEN[3] WEN[2] WEN[1] WEN[0] Q[31] Q[30] Q[29] Q[28] Q[27] Q[26] Q[25] Q[24] Q[23] Q[22] Q[21] Q[20] Q[19] Q[18] Q[17] Q[16] Q[15] Q[14] Q[13] Q[12] Q[11] Q[10] Q[9] Q[8] Q[7] Q[6] Q[5] Q[4] Q[3] Q[2] Q[1] Q[0] VDD VSS sram_256x32
CQ0 Q[0] 0 20f
CQ1 Q[1] 0 20f
CQ2 Q[2] 0 20f
CQ3 Q[3] 0 20f
CQ4 Q[4] 0 20f
CQ5 Q[5] 0 20f
CQ6 Q[6] 0 20f
CQ7 Q[7] 0 20f
CQ8 Q[8] 0 20f
CQ9 Q[9] 0 20f
CQ10 Q[10] 0 20f
CQ11 Q[11] 0 20f
CQ12 Q[12] 0 20f
CQ13 Q[13] 0 20f
CQ14 Q[14] 0 20f
CQ15 Q[15] 0 20f
CQ16 Q[16] 0 20f
CQ17 Q[17] 0 20f
CQ18 Q[18] 0 20f
CQ19 Q[19] 0 20f
CQ20 Q[20] 0 20f
CQ21 Q[21] 0 20f
CQ22 Q[22] 0 20f
CQ23 Q[23] 0 20f
CQ24 Q[24] 0 20f
CQ25 Q[25] 0 20f
CQ26 Q[26] 0 20f
CQ27 Q[27] 0 20f
CQ28 Q[28] 0 20f
CQ29 Q[29] 0 20f
CQ30 Q[30] 0 20f
CQ31 Q[31] 0 20f

.option method=gear reltol=2e-3 abstol=1e-12 itl4=100
.tran 0.02n 205n
.meas tran q0_op3 FIND v(Q[0]) AT=74n
.meas tran q1_op3 FIND v(Q[1]) AT=74n
.meas tran q2_op3 FIND v(Q[2]) AT=74n
.meas tran q3_op3 FIND v(Q[3]) AT=74n
.meas tran q4_op3 FIND v(Q[4]) AT=74n
.meas tran q5_op3 FIND v(Q[5]) AT=74n
.meas tran q6_op3 FIND v(Q[6]) AT=74n
.meas tran q7_op3 FIND v(Q[7]) AT=74n
.meas tran q8_op3 FIND v(Q[8]) AT=74n
.meas tran q9_op3 FIND v(Q[9]) AT=74n
.meas tran q10_op3 FIND v(Q[10]) AT=74n
.meas tran q11_op3 FIND v(Q[11]) AT=74n
.meas tran q12_op3 FIND v(Q[12]) AT=74n
.meas tran q13_op3 FIND v(Q[13]) AT=74n
.meas tran q14_op3 FIND v(Q[14]) AT=74n
.meas tran q15_op3 FIND v(Q[15]) AT=74n
.meas tran q16_op3 FIND v(Q[16]) AT=74n
.meas tran q17_op3 FIND v(Q[17]) AT=74n
.meas tran q18_op3 FIND v(Q[18]) AT=74n
.meas tran q19_op3 FIND v(Q[19]) AT=74n
.meas tran q20_op3 FIND v(Q[20]) AT=74n
.meas tran q21_op3 FIND v(Q[21]) AT=74n
.meas tran q22_op3 FIND v(Q[22]) AT=74n
.meas tran q23_op3 FIND v(Q[23]) AT=74n
.meas tran q24_op3 FIND v(Q[24]) AT=74n
.meas tran q25_op3 FIND v(Q[25]) AT=74n
.meas tran q26_op3 FIND v(Q[26]) AT=74n
.meas tran q27_op3 FIND v(Q[27]) AT=74n
.meas tran q28_op3 FIND v(Q[28]) AT=74n
.meas tran q29_op3 FIND v(Q[29]) AT=74n
.meas tran q30_op3 FIND v(Q[30]) AT=74n
.meas tran q31_op3 FIND v(Q[31]) AT=74n
.meas tran q0_op4 FIND v(Q[0]) AT=94n
.meas tran q1_op4 FIND v(Q[1]) AT=94n
.meas tran q2_op4 FIND v(Q[2]) AT=94n
.meas tran q3_op4 FIND v(Q[3]) AT=94n
.meas tran q4_op4 FIND v(Q[4]) AT=94n
.meas tran q5_op4 FIND v(Q[5]) AT=94n
.meas tran q6_op4 FIND v(Q[6]) AT=94n
.meas tran q7_op4 FIND v(Q[7]) AT=94n
.meas tran q8_op4 FIND v(Q[8]) AT=94n
.meas tran q9_op4 FIND v(Q[9]) AT=94n
.meas tran q10_op4 FIND v(Q[10]) AT=94n
.meas tran q11_op4 FIND v(Q[11]) AT=94n
.meas tran q12_op4 FIND v(Q[12]) AT=94n
.meas tran q13_op4 FIND v(Q[13]) AT=94n
.meas tran q14_op4 FIND v(Q[14]) AT=94n
.meas tran q15_op4 FIND v(Q[15]) AT=94n
.meas tran q16_op4 FIND v(Q[16]) AT=94n
.meas tran q17_op4 FIND v(Q[17]) AT=94n
.meas tran q18_op4 FIND v(Q[18]) AT=94n
.meas tran q19_op4 FIND v(Q[19]) AT=94n
.meas tran q20_op4 FIND v(Q[20]) AT=94n
.meas tran q21_op4 FIND v(Q[21]) AT=94n
.meas tran q22_op4 FIND v(Q[22]) AT=94n
.meas tran q23_op4 FIND v(Q[23]) AT=94n
.meas tran q24_op4 FIND v(Q[24]) AT=94n
.meas tran q25_op4 FIND v(Q[25]) AT=94n
.meas tran q26_op4 FIND v(Q[26]) AT=94n
.meas tran q27_op4 FIND v(Q[27]) AT=94n
.meas tran q28_op4 FIND v(Q[28]) AT=94n
.meas tran q29_op4 FIND v(Q[29]) AT=94n
.meas tran q30_op4 FIND v(Q[30]) AT=94n
.meas tran q31_op4 FIND v(Q[31]) AT=94n
.meas tran q0_op5 FIND v(Q[0]) AT=114n
.meas tran q1_op5 FIND v(Q[1]) AT=114n
.meas tran q2_op5 FIND v(Q[2]) AT=114n
.meas tran q3_op5 FIND v(Q[3]) AT=114n
.meas tran q4_op5 FIND v(Q[4]) AT=114n
.meas tran q5_op5 FIND v(Q[5]) AT=114n
.meas tran q6_op5 FIND v(Q[6]) AT=114n
.meas tran q7_op5 FIND v(Q[7]) AT=114n
.meas tran q8_op5 FIND v(Q[8]) AT=114n
.meas tran q9_op5 FIND v(Q[9]) AT=114n
.meas tran q10_op5 FIND v(Q[10]) AT=114n
.meas tran q11_op5 FIND v(Q[11]) AT=114n
.meas tran q12_op5 FIND v(Q[12]) AT=114n
.meas tran q13_op5 FIND v(Q[13]) AT=114n
.meas tran q14_op5 FIND v(Q[14]) AT=114n
.meas tran q15_op5 FIND v(Q[15]) AT=114n
.meas tran q16_op5 FIND v(Q[16]) AT=114n
.meas tran q17_op5 FIND v(Q[17]) AT=114n
.meas tran q18_op5 FIND v(Q[18]) AT=114n
.meas tran q19_op5 FIND v(Q[19]) AT=114n
.meas tran q20_op5 FIND v(Q[20]) AT=114n
.meas tran q21_op5 FIND v(Q[21]) AT=114n
.meas tran q22_op5 FIND v(Q[22]) AT=114n
.meas tran q23_op5 FIND v(Q[23]) AT=114n
.meas tran q24_op5 FIND v(Q[24]) AT=114n
.meas tran q25_op5 FIND v(Q[25]) AT=114n
.meas tran q26_op5 FIND v(Q[26]) AT=114n
.meas tran q27_op5 FIND v(Q[27]) AT=114n
.meas tran q28_op5 FIND v(Q[28]) AT=114n
.meas tran q29_op5 FIND v(Q[29]) AT=114n
.meas tran q30_op5 FIND v(Q[30]) AT=114n
.meas tran q31_op5 FIND v(Q[31]) AT=114n
.meas tran q0_op6 FIND v(Q[0]) AT=134n
.meas tran q1_op6 FIND v(Q[1]) AT=134n
.meas tran q2_op6 FIND v(Q[2]) AT=134n
.meas tran q3_op6 FIND v(Q[3]) AT=134n
.meas tran q4_op6 FIND v(Q[4]) AT=134n
.meas tran q5_op6 FIND v(Q[5]) AT=134n
.meas tran q6_op6 FIND v(Q[6]) AT=134n
.meas tran q7_op6 FIND v(Q[7]) AT=134n
.meas tran q8_op6 FIND v(Q[8]) AT=134n
.meas tran q9_op6 FIND v(Q[9]) AT=134n
.meas tran q10_op6 FIND v(Q[10]) AT=134n
.meas tran q11_op6 FIND v(Q[11]) AT=134n
.meas tran q12_op6 FIND v(Q[12]) AT=134n
.meas tran q13_op6 FIND v(Q[13]) AT=134n
.meas tran q14_op6 FIND v(Q[14]) AT=134n
.meas tran q15_op6 FIND v(Q[15]) AT=134n
.meas tran q16_op6 FIND v(Q[16]) AT=134n
.meas tran q17_op6 FIND v(Q[17]) AT=134n
.meas tran q18_op6 FIND v(Q[18]) AT=134n
.meas tran q19_op6 FIND v(Q[19]) AT=134n
.meas tran q20_op6 FIND v(Q[20]) AT=134n
.meas tran q21_op6 FIND v(Q[21]) AT=134n
.meas tran q22_op6 FIND v(Q[22]) AT=134n
.meas tran q23_op6 FIND v(Q[23]) AT=134n
.meas tran q24_op6 FIND v(Q[24]) AT=134n
.meas tran q25_op6 FIND v(Q[25]) AT=134n
.meas tran q26_op6 FIND v(Q[26]) AT=134n
.meas tran q27_op6 FIND v(Q[27]) AT=134n
.meas tran q28_op6 FIND v(Q[28]) AT=134n
.meas tran q29_op6 FIND v(Q[29]) AT=134n
.meas tran q30_op6 FIND v(Q[30]) AT=134n
.meas tran q31_op6 FIND v(Q[31]) AT=134n
.meas tran q0_op7 FIND v(Q[0]) AT=154n
.meas tran q1_op7 FIND v(Q[1]) AT=154n
.meas tran q2_op7 FIND v(Q[2]) AT=154n
.meas tran q3_op7 FIND v(Q[3]) AT=154n
.meas tran q4_op7 FIND v(Q[4]) AT=154n
.meas tran q5_op7 FIND v(Q[5]) AT=154n
.meas tran q6_op7 FIND v(Q[6]) AT=154n
.meas tran q7_op7 FIND v(Q[7]) AT=154n
.meas tran q8_op7 FIND v(Q[8]) AT=154n
.meas tran q9_op7 FIND v(Q[9]) AT=154n
.meas tran q10_op7 FIND v(Q[10]) AT=154n
.meas tran q11_op7 FIND v(Q[11]) AT=154n
.meas tran q12_op7 FIND v(Q[12]) AT=154n
.meas tran q13_op7 FIND v(Q[13]) AT=154n
.meas tran q14_op7 FIND v(Q[14]) AT=154n
.meas tran q15_op7 FIND v(Q[15]) AT=154n
.meas tran q16_op7 FIND v(Q[16]) AT=154n
.meas tran q17_op7 FIND v(Q[17]) AT=154n
.meas tran q18_op7 FIND v(Q[18]) AT=154n
.meas tran q19_op7 FIND v(Q[19]) AT=154n
.meas tran q20_op7 FIND v(Q[20]) AT=154n
.meas tran q21_op7 FIND v(Q[21]) AT=154n
.meas tran q22_op7 FIND v(Q[22]) AT=154n
.meas tran q23_op7 FIND v(Q[23]) AT=154n
.meas tran q24_op7 FIND v(Q[24]) AT=154n
.meas tran q25_op7 FIND v(Q[25]) AT=154n
.meas tran q26_op7 FIND v(Q[26]) AT=154n
.meas tran q27_op7 FIND v(Q[27]) AT=154n
.meas tran q28_op7 FIND v(Q[28]) AT=154n
.meas tran q29_op7 FIND v(Q[29]) AT=154n
.meas tran q30_op7 FIND v(Q[30]) AT=154n
.meas tran q31_op7 FIND v(Q[31]) AT=154n
.meas tran q0_op8 FIND v(Q[0]) AT=174n
.meas tran q1_op8 FIND v(Q[1]) AT=174n
.meas tran q2_op8 FIND v(Q[2]) AT=174n
.meas tran q3_op8 FIND v(Q[3]) AT=174n
.meas tran q4_op8 FIND v(Q[4]) AT=174n
.meas tran q5_op8 FIND v(Q[5]) AT=174n
.meas tran q6_op8 FIND v(Q[6]) AT=174n
.meas tran q7_op8 FIND v(Q[7]) AT=174n
.meas tran q8_op8 FIND v(Q[8]) AT=174n
.meas tran q9_op8 FIND v(Q[9]) AT=174n
.meas tran q10_op8 FIND v(Q[10]) AT=174n
.meas tran q11_op8 FIND v(Q[11]) AT=174n
.meas tran q12_op8 FIND v(Q[12]) AT=174n
.meas tran q13_op8 FIND v(Q[13]) AT=174n
.meas tran q14_op8 FIND v(Q[14]) AT=174n
.meas tran q15_op8 FIND v(Q[15]) AT=174n
.meas tran q16_op8 FIND v(Q[16]) AT=174n
.meas tran q17_op8 FIND v(Q[17]) AT=174n
.meas tran q18_op8 FIND v(Q[18]) AT=174n
.meas tran q19_op8 FIND v(Q[19]) AT=174n
.meas tran q20_op8 FIND v(Q[20]) AT=174n
.meas tran q21_op8 FIND v(Q[21]) AT=174n
.meas tran q22_op8 FIND v(Q[22]) AT=174n
.meas tran q23_op8 FIND v(Q[23]) AT=174n
.meas tran q24_op8 FIND v(Q[24]) AT=174n
.meas tran q25_op8 FIND v(Q[25]) AT=174n
.meas tran q26_op8 FIND v(Q[26]) AT=174n
.meas tran q27_op8 FIND v(Q[27]) AT=174n
.meas tran q28_op8 FIND v(Q[28]) AT=174n
.meas tran q29_op8 FIND v(Q[29]) AT=174n
.meas tran q30_op8 FIND v(Q[30]) AT=174n
.meas tran q31_op8 FIND v(Q[31]) AT=174n
.meas tran q0_op9 FIND v(Q[0]) AT=194n
.meas tran q1_op9 FIND v(Q[1]) AT=194n
.meas tran q2_op9 FIND v(Q[2]) AT=194n
.meas tran q3_op9 FIND v(Q[3]) AT=194n
.meas tran q4_op9 FIND v(Q[4]) AT=194n
.meas tran q5_op9 FIND v(Q[5]) AT=194n
.meas tran q6_op9 FIND v(Q[6]) AT=194n
.meas tran q7_op9 FIND v(Q[7]) AT=194n
.meas tran q8_op9 FIND v(Q[8]) AT=194n
.meas tran q9_op9 FIND v(Q[9]) AT=194n
.meas tran q10_op9 FIND v(Q[10]) AT=194n
.meas tran q11_op9 FIND v(Q[11]) AT=194n
.meas tran q12_op9 FIND v(Q[12]) AT=194n
.meas tran q13_op9 FIND v(Q[13]) AT=194n
.meas tran q14_op9 FIND v(Q[14]) AT=194n
.meas tran q15_op9 FIND v(Q[15]) AT=194n
.meas tran q16_op9 FIND v(Q[16]) AT=194n
.meas tran q17_op9 FIND v(Q[17]) AT=194n
.meas tran q18_op9 FIND v(Q[18]) AT=194n
.meas tran q19_op9 FIND v(Q[19]) AT=194n
.meas tran q20_op9 FIND v(Q[20]) AT=194n
.meas tran q21_op9 FIND v(Q[21]) AT=194n
.meas tran q22_op9 FIND v(Q[22]) AT=194n
.meas tran q23_op9 FIND v(Q[23]) AT=194n
.meas tran q24_op9 FIND v(Q[24]) AT=194n
.meas tran q25_op9 FIND v(Q[25]) AT=194n
.meas tran q26_op9 FIND v(Q[26]) AT=194n
.meas tran q27_op9 FIND v(Q[27]) AT=194n
.meas tran q28_op9 FIND v(Q[28]) AT=194n
.meas tran q29_op9 FIND v(Q[29]) AT=194n
.meas tran q30_op9 FIND v(Q[30]) AT=194n
.meas tran q31_op9 FIND v(Q[31]) AT=194n
.end
