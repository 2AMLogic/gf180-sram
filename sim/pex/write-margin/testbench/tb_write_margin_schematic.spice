* By-hand PEX write-margin testbench, SCHEMATIC leg (issue #95).
*
* `klt pex` cannot run the ratified sim/write-margin/testbench/tb_write_margin.spice
* directly for post-layout PEX -- its bisection search is a `.control`-block
* algorithm (`dowhile`/`alterparam`) with no `.meas`-only equivalent klt
* sim's request format can express (see sim/pex/README.md's "write-margin:
* by-hand extraction workflow" section). Per issue #95's own suggested
* path, this instead runs the *existing* sim/lib/run_corner_sweep.sh
* machinery by hand against this file and its sibling
* tb_write_margin_extracted.spice, replicating `klt pex`'s intent
* (schematic-vs-extracted delta) without `klt pex`'s own orchestration.
*
* This is a NEW, PARALLEL artifact -- it does not modify, and is not a
* substitute for, the ratified #24 signoff testbench. That file remains
* the T1-item-9 evidence for write margin.
*
* Structurally identical to the ratified testbench (same VBL/VBLB/VWL
* phases, same bisection search, same corner.inc/@@REPO_ROOT@@ mechanism --
* see that file's own header for the full rationale of each) with exactly
* one difference: the DUT is instantiated via `.SUBCKT`/`X` instead of
* `.include`d flat, so this same file's structure (differing only in the
* DUT `.include` target) also has a matching EXTRACTED-side sibling
* (tb_write_margin_extracted.spice) whose `.SUBCKT sram_bitcell_6t BL BLB Q
* QB VDD VSS WL` interface this X-instantiation binds identically either
* way -- the same DUT-swap convention docs/cli/pex.md's "The DUT .include
* swap" describes, applied by hand instead of by `klt pex` itself.
*
* Corner selection: see ./corner.inc, generated by
* sim/lib/run_corner_sweep.sh.
.include './corner.inc'

VVDD VDD 0 DC VDDC

* klt extract --parasitics lands the extracted sibling's substrate-coupling
* capacitance on an internal, un-pinned `vsubs` node with no DC path to any
* reference (see sim/pex/access-time/testbench/tb_write_access_time.pex.spice's
* header for the full explanation and sim/pex/README.md's "New finding"
* section). Declared unconditionally on both legs for a byte-identical
* testbench body pair -- confirmed harmless here (no floating nodes on the
* schematic leg).
.options rshunt=1e12

* DUT: exactly one more `.include` line beyond corner.inc's own (matching
* the ratified testbench's own two-`.include` structure) -- the
* klt-pex-compatible `.SUBCKT`-wrapped copy of bitcell_6t.spice's own
* device cards (sim/pex/access-time/dut/bitcell_6t_subckt.spice, reused
* here rather than duplicated -- see that file's own generator for
* provenance). `@@REPO_ROOT@@` substituted the same way the ratified
* testbench's own DUT `.include` is -- see that file's header.
.include '@@REPO_ROOT@@/sim/pex/access-time/dut/bitcell_6t_subckt.spice'
XDUT BL BLB Q QB VDD VSS WL sram_bitcell_6t

* Phase 1 [0, 2n]: preset the cell to '1' (Q=VDD, QB=0) with a strong,
*   full-VDD differential write pulse -- see the ratified testbench's own
*   header for why a preset write, not `.ic`, is used here.
* Phase 2 idle [2n, 4n]: WL deasserted.
* Phase 3 [4n, 6n]: the write-margin trial -- see the ratified testbench's
*   own header for the full description of VWRITE's role.
.param VWRITE=0
VBL BL 0 PWL(0 VDDC 4n VDDC 4.1n VWRITE 5.9n VWRITE 6n VDDC 8n VDDC)
VBLB BLB 0 PWL(0 0 4n 0 4.1n VDDC 8n VDDC)
VWL WL 0 PWL(0 0 0.1n VDDC 1.9n VDDC 2n 0 4n 0 4.1n VDDC 5.9n VDDC 6n 0 8n 0)

.control
* See the ratified testbench's own header for the full derivation and
* rationale of every step below -- this control block is byte-identical to
* it (same bisection search, same monotonicity assumption, same
* resolution, same open-result handling), reproduced here only because
* run_corner_sweep.sh reads it from THIS file, not the ratified one.
let vddc_ctl = @vvdd[dc]

let vw_lo = 0
let vw_hi = vddc_ctl
let vw_mid = 0
let q_lo = 0
let q_hi = 0
let q_mid = 0
let iter = 0
let wtv_bits = 14
let wtv_resolution = vddc_ctl/16384
let wtv_fail = 0 - wtv_resolution

alterparam VWRITE = 0
reset
tran 0.02n 8n
let q_lo = v(Q)[length(v(Q))-1]

alterparam VWRITE = $&vddc_ctl
reset
tran 0.02n 8n
let q_hi = v(Q)[length(v(Q))-1]

dowhile iter < wtv_bits
  let vw_mid = (vw_lo + vw_hi)/2
  alterparam VWRITE = $&vw_mid
  reset
  tran 0.02n 8n
  let q_mid = v(Q)[length(v(Q))-1]
  if q_mid <= (vddc_ctl/2)
    let vw_lo = vw_mid
  else
    let vw_hi = vw_mid
  end
  let iter = iter + 1
end

if q_lo > (vddc_ctl/2)
  echo RESULT: write_trip_voltage_v = $&wtv_fail
  echo RESULT: write_vdd_v = $&vddc_ctl
else
  if q_hi <= (vddc_ctl/2)
    echo RESULT-ERROR: write_trip_voltage -- write succeeded even with no bit-line differential (VWRITE = VDD); fixture or corner did not produce a valid trip point
  else
    echo RESULT: write_trip_voltage_v = $&vw_lo
    echo RESULT: write_vdd_v = $&vddc_ctl
  end
end
.endc
.end
