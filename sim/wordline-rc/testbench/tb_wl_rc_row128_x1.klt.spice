* Wordline RC gate: row128, extracted Poly2 R -- klt sim circuit BODY (issue #204;
* spec/periphery-architecture.md "Wordline RC gate"). A real `rowdrv`
* (design/netlist/rowdrv.spice, W=6u/3u output stage) drives the extracted wordline from
* its landing-pad end. Pulse 1 is the 2.0 ns write-pulse floor of
* spec/write-pulse-width-decision.md; pulse 2 is 5.88 ns, the wl_en width the
* control block makes at ss_125c_2.97v (sim/macro-smoke record 20261018-082301-37ba562).
* Both rowdrv inputs get the pulse with 0.1 ns edges (an ideal stand-in for predecode).
.include '../../../design/netlist/rowdrv.spice'
.include '../dut/wl_row_128.x1.ported.spice'
.options rshunt=1e12

* PDK default params normally supplied by design.ngspice (via corner.inc)
.param sw_stat_global=0
.param sw_stat_mismatch=0
.param mc_skew=3
.param res_mc_skew=3
.param cap_mc_skew=3
.param fnoicor=0

VVDD VDD 0 DC 3.3
V1IN in1 0 PWL(0 0 1n 0 1.1n 1 3n 1 3.1n 0 12n 0 12.1n 1 17.88n 1 17.98n 0 30n 0)
BIN IN 0 V='v(VDD)*v(in1)'
XDRV IN IN wl_drv VDD 0 rowdrv
Rpad wl_drv wl_pad 1m
XA VDD VDD VDD VDD VDD VDD VDD VDD VDD VDD VDD VDD VDD VDD VDD VDD VDD VDD VDD VDD VDD VDD VDD VDD VDD VDD VDD VDD VDD VDD VDD VDD VDD VDD VDD VDD VDD VDD VDD VDD VDD VDD VDD VDD VDD VDD VDD VDD VDD VDD VDD VDD VDD VDD VDD VDD VDD VDD VDD VDD VDD VDD VDD VDD VDD VDD VDD VDD VDD VDD VDD VDD VDD VDD VDD VDD VDD VDD VDD VDD VDD VDD VDD VDD VDD VDD VDD VDD VDD VDD VDD VDD VDD VDD VDD VDD VDD VDD VDD VDD VDD VDD VDD VDD VDD VDD VDD VDD VDD VDD VDD VDD VDD VDD VDD VDD VDD VDD VDD VDD VDD VDD VDD VDD VDD VDD VDD VDD VDD VDD VDD VDD VDD VDD VDD VDD VDD VDD VDD VDD VDD VDD VDD VDD VDD VDD VDD VDD VDD VDD VDD VDD VDD VDD VDD VDD VDD VDD VDD VDD VDD VDD VDD VDD VDD VDD VDD VDD VDD VDD VDD VDD VDD VDD VDD VDD VDD VDD VDD VDD VDD VDD VDD VDD VDD VDD VDD VDD VDD VDD VDD VDD VDD VDD VDD VDD VDD VDD VDD VDD VDD VDD VDD VDD VDD VDD VDD VDD VDD VDD VDD VDD VDD VDD VDD VDD VDD VDD VDD VDD VDD VDD VDD VDD VDD VDD VDD VDD VDD VDD VDD VDD VDD VDD VDD VDD VDD VDD VDD VDD VDD VDD VDD VDD VDD VDD VDD VDD VDD VDD VDD VDD VDD VDD VDD VDD VDD VSS mid_A wl_pad wl_far wl_row_128

* digitised probes (1 when above 10 / 50 / 90 % of VDD), one set per pulse window
Bd_in_1 d_in_1 0 V='(v(IN) > v(VDD)/2 ? 1 : 0) * (time < 10n ? 1 : 0)'
Bd_drv_1 d_drv_1 0 V='(v(wl_drv) > v(VDD)/2 ? 1 : 0) * (time < 10n ? 1 : 0)'
Bd_far_1 d_far_1 0 V='(v(wl_far) > v(VDD)/2 ? 1 : 0) * (time < 10n ? 1 : 0)'
Bd_far10_1 d_far10_1 0 V='(v(wl_far) > 0.1*v(VDD) ? 1 : 0) * (time < 10n ? 1 : 0)'
Bd_far90_1 d_far90_1 0 V='(v(wl_far) > 0.9*v(VDD) ? 1 : 0) * (time < 10n ? 1 : 0)'
Bd_in_2 d_in_2 0 V='(v(IN) > v(VDD)/2 ? 1 : 0) * (time >= 10n ? 1 : 0)'
Bd_drv_2 d_drv_2 0 V='(v(wl_drv) > v(VDD)/2 ? 1 : 0) * (time >= 10n ? 1 : 0)'
Bd_far_2 d_far_2 0 V='(v(wl_far) > v(VDD)/2 ? 1 : 0) * (time >= 10n ? 1 : 0)'
Bd_far10_2 d_far10_2 0 V='(v(wl_far) > 0.1*v(VDD) ? 1 : 0) * (time >= 10n ? 1 : 0)'
Bd_far90_2 d_far90_2 0 V='(v(wl_far) > 0.9*v(VDD) ? 1 : 0) * (time >= 10n ? 1 : 0)'
