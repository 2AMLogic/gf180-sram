* extracted by klt extract --deck gf180mcu
* parasitic model (--parasitics):
* - capacitance: net-to-ground for every net's own (non-coupled) area/perimeter, plus net-to-net for the vertical-overlap coupling `coupling` describes below -- a coupled net pair gets a direct capacitor between their two hub nodes, not just capacitors to the deck's ground/substrate net
* - coupling: vertical overlap (crossover) unconditionally -- where one net's conductor on an adjacent metal level sits directly over another *distinct* net's conductor, that overlap area is charged between the two nets instead of to ground (issue #760) -- plus lateral (same-layer, sidewall) coupling, but only for a net pair naming one of the caller's declared `--critical-net` nets (issue #976): facing-edge length within that layer's own minimum-spacing lookback is charged between the two nets, *additively* (not deducted from either net's substrate fringe term, unlike the vertical case -- a known simplification). Any same-layer pair with neither side named `--critical-net`, and fringe shielding in general, are still not modelled
* - resistance: single lumped series resistance per net, distributed as a star across that net's device terminals (issue #592) -- not a per-segment, distributed RC ladder, *unless* `--distributed-rc` names this net via `--critical-net` (issue #977, Epic #709 Phase 2b): then the net's terminals are ordered along their approximate physical spread and its total R/C is broken into a chain of per-segment resistors (segment length proportional to inter-terminal distance) with a ground capacitor at each terminal node (proportional to its adjacent segment length/2), instead of one star hub -- still an approximation (terminal position is a device-placement proxy, not true per-segment routing geometry), but a strictly finer-grained one than the single-hub star
* - frequency: quasi-static -- one frequency-independent R and C per net; no skin effect, no distributed transmission-line behavior
* - substrate tie: 1e+12 ohm to ground -- the substrate is capacitively floating in transient analysis (DC reference only); see --substrate-tie-ohms
.GLOBAL vsubs

* cell wl_row_64
* pin BL0
* pin BL1
* pin BL10
* pin BL11
* pin BL12
* pin BL13
* pin BL14
* pin BL15
* pin BL16
* pin BL17
* pin BL18
* pin BL19
* pin BL2
* pin BL20
* pin BL21
* pin BL22
* pin BL23
* pin BL24
* pin BL25
* pin BL26
* pin BL27
* pin BL28
* pin BL29
* pin BL3
* pin BL30
* pin BL31
* pin BL32
* pin BL33
* pin BL34
* pin BL35
* pin BL36
* pin BL37
* pin BL38
* pin BL39
* pin BL4
* pin BL40
* pin BL41
* pin BL42
* pin BL43
* pin BL44
* pin BL45
* pin BL46
* pin BL47
* pin BL48
* pin BL49
* pin BL5
* pin BL50
* pin BL51
* pin BL52
* pin BL53
* pin BL54
* pin BL55
* pin BL56
* pin BL57
* pin BL58
* pin BL59
* pin BL6
* pin BL60
* pin BL61
* pin BL62
* pin BL63
* pin BL7
* pin BL8
* pin BL9
* pin BLB0
* pin BLB1
* pin BLB10
* pin BLB11
* pin BLB12
* pin BLB13
* pin BLB14
* pin BLB15
* pin BLB16
* pin BLB17
* pin BLB18
* pin BLB19
* pin BLB2
* pin BLB20
* pin BLB21
* pin BLB22
* pin BLB23
* pin BLB24
* pin BLB25
* pin BLB26
* pin BLB27
* pin BLB28
* pin BLB29
* pin BLB3
* pin BLB30
* pin BLB31
* pin BLB32
* pin BLB33
* pin BLB34
* pin BLB35
* pin BLB36
* pin BLB37
* pin BLB38
* pin BLB39
* pin BLB4
* pin BLB40
* pin BLB41
* pin BLB42
* pin BLB43
* pin BLB44
* pin BLB45
* pin BLB46
* pin BLB47
* pin BLB48
* pin BLB49
* pin BLB5
* pin BLB50
* pin BLB51
* pin BLB52
* pin BLB53
* pin BLB54
* pin BLB55
* pin BLB56
* pin BLB57
* pin BLB58
* pin BLB59
* pin BLB6
* pin BLB60
* pin BLB61
* pin BLB62
* pin BLB63
* pin BLB7
* pin BLB8
* pin BLB9
* pin VDD
* pin VSS
* pin WL0
.SUBCKT wl_row_64 BL0 BL1 BL10 BL11 BL12 BL13 BL14 BL15 BL16 BL17 BL18 BL19 BL2
+ BL20 BL21 BL22 BL23 BL24 BL25 BL26 BL27 BL28 BL29 BL3 BL30 BL31 BL32 BL33
+ BL34 BL35 BL36 BL37 BL38 BL39 BL4 BL40 BL41 BL42 BL43 BL44 BL45 BL46 BL47
+ BL48 BL49 BL5 BL50 BL51 BL52 BL53 BL54 BL55 BL56 BL57 BL58 BL59 BL6 BL60 BL61
+ BL62 BL63 BL7 BL8 BL9 BLB0 BLB1 BLB10 BLB11 BLB12 BLB13 BLB14 BLB15 BLB16
+ BLB17 BLB18 BLB19 BLB2 BLB20 BLB21 BLB22 BLB23 BLB24 BLB25 BLB26 BLB27 BLB28
+ BLB29 BLB3 BLB30 BLB31 BLB32 BLB33 BLB34 BLB35 BLB36 BLB37 BLB38 BLB39 BLB4
+ BLB40 BLB41 BLB42 BLB43 BLB44 BLB45 BLB46 BLB47 BLB48 BLB49 BLB5 BLB50 BLB51
+ BLB52 BLB53 BLB54 BLB55 BLB56 BLB57 BLB58 BLB59 BLB6 BLB60 BLB61 BLB62 BLB63
+ BLB7 BLB8 BLB9 VDD VSS WL0
* device instance $1 r0 *1 1.21,1.77 nfet
X$1 \$69__t4 WL0__t0 BL0__t0 VSS__t128 nfet_03v3 L=0.28U W=0.24U AS=0.1684P
+ AD=0.1022P PS=1.72U PD=0.96U
* device instance $2 r0 *1 4.11,1.77 nfet
X$2 BLB0__t0 WL0__t1 \$4__t3 VSS__t192 nfet_03v3 L=0.28U W=0.24U AS=0.1022P
+ AD=0.1684P PS=0.96U PD=1.72U
* device instance $3 r0 *1 2.07,1.83 nfet
X$3 VSS__t1 \$4__t0 \$69__t3 VSS__t256 nfet_03v3 L=0.28U W=0.36U AS=0.1022P
+ AD=0.169P PS=0.96U PD=1.28U
* device instance $4 r0 *1 3.25,1.83 nfet
X$4 \$4__t4 \$69__t0 VSS__t0 VSS__t320 nfet_03v3 L=0.28U W=0.36U AS=0.169P
+ AD=0.1022P PS=1.28U PD=0.96U
* device instance $5 r0 *1 5.67,1.77 nfet
X$5 \$72__t3 WL0__t111 BL1__t0 VSS__t129 nfet_03v3 L=0.28U W=0.24U AS=0.1684P
+ AD=0.1022P PS=1.72U PD=0.96U
* device instance $6 r0 *1 8.57,1.77 nfet
X$6 BLB1__t0 WL0__t44 \$5__t4 VSS__t193 nfet_03v3 L=0.28U W=0.24U AS=0.1022P
+ AD=0.1684P PS=0.96U PD=1.72U
* device instance $7 r0 *1 6.53,1.83 nfet
X$7 VSS__t43 \$5__t2 \$72__t4 VSS__t257 nfet_03v3 L=0.28U W=0.36U AS=0.1022P
+ AD=0.169P PS=0.96U PD=1.28U
* device instance $8 r0 *1 7.71,1.83 nfet
X$8 \$5__t3 \$72__t2 VSS__t77 VSS__t321 nfet_03v3 L=0.28U W=0.36U AS=0.169P
+ AD=0.1022P PS=1.28U PD=0.96U
* device instance $9 r0 *1 10.13,1.77 nfet
X$9 \$75__t3 WL0__t113 BL2__t0 VSS__t130 nfet_03v3 L=0.28U W=0.24U AS=0.1684P
+ AD=0.1022P PS=1.72U PD=0.96U
* device instance $10 r0 *1 13.03,1.77 nfet
X$10 BLB2__t0 WL0__t42 \$6__t4 VSS__t194 nfet_03v3 L=0.28U W=0.24U AS=0.1022P
+ AD=0.1684P PS=0.96U PD=1.72U
* device instance $11 r0 *1 10.99,1.83 nfet
X$11 VSS__t40 \$6__t2 \$75__t4 VSS__t258 nfet_03v3 L=0.28U W=0.36U AS=0.1022P
+ AD=0.169P PS=0.96U PD=1.28U
* device instance $12 r0 *1 12.17,1.83 nfet
X$12 \$6__t3 \$75__t2 VSS__t76 VSS__t322 nfet_03v3 L=0.28U W=0.36U AS=0.169P
+ AD=0.1022P PS=1.28U PD=0.96U
* device instance $13 r0 *1 14.59,1.77 nfet
X$13 \$78__t3 WL0__t114 BL3__t0 VSS__t131 nfet_03v3 L=0.28U W=0.24U AS=0.1684P
+ AD=0.1022P PS=1.72U PD=0.96U
* device instance $14 r0 *1 17.49,1.77 nfet
X$14 BLB3__t0 WL0__t41 \$7__t4 VSS__t195 nfet_03v3 L=0.28U W=0.24U AS=0.1022P
+ AD=0.1684P PS=0.96U PD=1.72U
* device instance $15 r0 *1 15.45,1.83 nfet
X$15 VSS__t38 \$7__t2 \$78__t4 VSS__t259 nfet_03v3 L=0.28U W=0.36U AS=0.1022P
+ AD=0.169P PS=0.96U PD=1.28U
* device instance $16 r0 *1 16.63,1.83 nfet
X$16 \$7__t3 \$78__t2 VSS__t74 VSS__t323 nfet_03v3 L=0.28U W=0.36U AS=0.169P
+ AD=0.1022P PS=1.28U PD=0.96U
* device instance $17 r0 *1 19.05,1.77 nfet
X$17 \$81__t3 WL0__t117 BL4__t0 VSS__t132 nfet_03v3 L=0.28U W=0.24U AS=0.1684P
+ AD=0.1022P PS=1.72U PD=0.96U
* device instance $18 r0 *1 21.95,1.77 nfet
X$18 BLB4__t0 WL0__t27 \$8__t4 VSS__t196 nfet_03v3 L=0.28U W=0.24U AS=0.1022P
+ AD=0.1684P PS=0.96U PD=1.72U
* device instance $19 r0 *1 19.91,1.83 nfet
X$19 VSS__t5 \$8__t2 \$81__t4 VSS__t260 nfet_03v3 L=0.28U W=0.36U AS=0.1022P
+ AD=0.169P PS=0.96U PD=1.28U
* device instance $20 r0 *1 21.09,1.83 nfet
X$20 \$8__t3 \$81__t2 VSS__t91 VSS__t324 nfet_03v3 L=0.28U W=0.36U AS=0.169P
+ AD=0.1022P PS=1.28U PD=0.96U
* device instance $21 r0 *1 23.51,1.77 nfet
X$21 \$84__t3 WL0__t89 BL5__t0 VSS__t133 nfet_03v3 L=0.28U W=0.24U AS=0.1684P
+ AD=0.1022P PS=1.72U PD=0.96U
* device instance $22 r0 *1 26.41,1.77 nfet
X$22 BLB5__t0 WL0__t26 \$9__t4 VSS__t197 nfet_03v3 L=0.28U W=0.24U AS=0.1022P
+ AD=0.1684P PS=0.96U PD=1.72U
* device instance $23 r0 *1 24.37,1.83 nfet
X$23 VSS__t8 \$9__t2 \$84__t4 VSS__t261 nfet_03v3 L=0.28U W=0.36U AS=0.1022P
+ AD=0.169P PS=0.96U PD=1.28U
* device instance $24 r0 *1 25.55,1.83 nfet
X$24 \$9__t3 \$84__t2 VSS__t88 VSS__t325 nfet_03v3 L=0.28U W=0.36U AS=0.169P
+ AD=0.1022P PS=1.28U PD=0.96U
* device instance $25 r0 *1 27.97,1.77 nfet
X$25 \$87__t3 WL0__t90 BL6__t0 VSS__t134 nfet_03v3 L=0.28U W=0.24U AS=0.1684P
+ AD=0.1022P PS=1.72U PD=0.96U
* device instance $26 r0 *1 30.87,1.77 nfet
X$26 BLB6__t0 WL0__t24 \$10__t4 VSS__t198 nfet_03v3 L=0.28U W=0.24U AS=0.1022P
+ AD=0.1684P PS=0.96U PD=1.72U
* device instance $27 r0 *1 28.83,1.83 nfet
X$27 VSS__t6 \$10__t2 \$87__t4 VSS__t262 nfet_03v3 L=0.28U W=0.36U AS=0.1022P
+ AD=0.169P PS=0.96U PD=1.28U
* device instance $28 r0 *1 30.01,1.83 nfet
X$28 \$10__t3 \$87__t2 VSS__t85 VSS__t326 nfet_03v3 L=0.28U W=0.36U AS=0.169P
+ AD=0.1022P PS=1.28U PD=0.96U
* device instance $29 r0 *1 32.43,1.77 nfet
X$29 \$90__t3 WL0__t91 BL7__t0 VSS__t135 nfet_03v3 L=0.28U W=0.24U AS=0.1684P
+ AD=0.1022P PS=1.72U PD=0.96U
* device instance $30 r0 *1 35.33,1.77 nfet
X$30 BLB7__t0 WL0__t36 \$11__t4 VSS__t199 nfet_03v3 L=0.28U W=0.24U AS=0.1022P
+ AD=0.1684P PS=0.96U PD=1.72U
* device instance $31 r0 *1 33.29,1.83 nfet
X$31 VSS__t10 \$11__t2 \$90__t4 VSS__t263 nfet_03v3 L=0.28U W=0.36U AS=0.1022P
+ AD=0.169P PS=0.96U PD=1.28U
* device instance $32 r0 *1 34.47,1.83 nfet
X$32 \$11__t3 \$90__t2 VSS__t84 VSS__t327 nfet_03v3 L=0.28U W=0.36U AS=0.169P
+ AD=0.1022P PS=1.28U PD=0.96U
* device instance $33 r0 *1 36.89,1.77 nfet
X$33 \$93__t3 WL0__t92 BL8__t0 VSS__t136 nfet_03v3 L=0.28U W=0.24U AS=0.1684P
+ AD=0.1022P PS=1.72U PD=0.96U
* device instance $34 r0 *1 39.79,1.77 nfet
X$34 BLB8__t0 WL0__t51 \$12__t4 VSS__t200 nfet_03v3 L=0.28U W=0.24U AS=0.1022P
+ AD=0.1684P PS=0.96U PD=1.72U
* device instance $35 r0 *1 37.75,1.83 nfet
X$35 VSS__t30 \$12__t2 \$93__t4 VSS__t264 nfet_03v3 L=0.28U W=0.36U AS=0.1022P
+ AD=0.169P PS=0.96U PD=1.28U
* device instance $36 r0 *1 38.93,1.83 nfet
X$36 \$12__t3 \$93__t2 VSS__t86 VSS__t328 nfet_03v3 L=0.28U W=0.36U AS=0.169P
+ AD=0.1022P PS=1.28U PD=0.96U
* device instance $37 r0 *1 41.35,1.77 nfet
X$37 \$96__t3 WL0__t94 BL9__t0 VSS__t137 nfet_03v3 L=0.28U W=0.24U AS=0.1684P
+ AD=0.1022P PS=1.72U PD=0.96U
* device instance $38 r0 *1 44.25,1.77 nfet
X$38 BLB9__t0 WL0__t56 \$13__t4 VSS__t201 nfet_03v3 L=0.28U W=0.24U AS=0.1022P
+ AD=0.1684P PS=0.96U PD=1.72U
* device instance $39 r0 *1 42.21,1.83 nfet
X$39 VSS__t27 \$13__t2 \$96__t4 VSS__t265 nfet_03v3 L=0.28U W=0.36U AS=0.1022P
+ AD=0.169P PS=0.96U PD=1.28U
* device instance $40 r0 *1 43.39,1.83 nfet
X$40 \$13__t3 \$96__t2 VSS__t89 VSS__t329 nfet_03v3 L=0.28U W=0.36U AS=0.169P
+ AD=0.1022P PS=1.28U PD=0.96U
* device instance $41 r0 *1 45.81,1.77 nfet
X$41 \$99__t3 WL0__t95 BL10__t0 VSS__t138 nfet_03v3 L=0.28U W=0.24U AS=0.1684P
+ AD=0.1022P PS=1.72U PD=0.96U
* device instance $42 r0 *1 48.71,1.77 nfet
X$42 BLB10__t0 WL0__t60 \$14__t4 VSS__t202 nfet_03v3 L=0.28U W=0.24U AS=0.1022P
+ AD=0.1684P PS=0.96U PD=1.72U
* device instance $43 r0 *1 46.67,1.83 nfet
X$43 VSS__t26 \$14__t2 \$99__t4 VSS__t266 nfet_03v3 L=0.28U W=0.36U AS=0.1022P
+ AD=0.169P PS=0.96U PD=1.28U
* device instance $44 r0 *1 47.85,1.83 nfet
X$44 \$14__t3 \$99__t2 VSS__t103 VSS__t330 nfet_03v3 L=0.28U W=0.36U AS=0.169P
+ AD=0.1022P PS=1.28U PD=0.96U
* device instance $45 r0 *1 50.27,1.77 nfet
X$45 \$102__t3 WL0__t97 BL11__t0 VSS__t139 nfet_03v3 L=0.28U W=0.24U AS=0.1684P
+ AD=0.1022P PS=1.72U PD=0.96U
* device instance $46 r0 *1 53.17,1.77 nfet
X$46 BLB11__t0 WL0__t63 \$15__t4 VSS__t203 nfet_03v3 L=0.28U W=0.24U AS=0.1022P
+ AD=0.1684P PS=0.96U PD=1.72U
* device instance $47 r0 *1 51.13,1.83 nfet
X$47 VSS__t23 \$15__t2 \$102__t4 VSS__t267 nfet_03v3 L=0.28U W=0.36U AS=0.1022P
+ AD=0.169P PS=0.96U PD=1.28U
* device instance $48 r0 *1 52.31,1.83 nfet
X$48 \$15__t3 \$102__t2 VSS__t93 VSS__t331 nfet_03v3 L=0.28U W=0.36U AS=0.169P
+ AD=0.1022P PS=1.28U PD=0.96U
* device instance $49 r0 *1 54.73,1.77 nfet
X$49 \$105__t3 WL0__t100 BL12__t0 VSS__t140 nfet_03v3 L=0.28U W=0.24U
+ AS=0.1684P AD=0.1022P PS=1.72U PD=0.96U
* device instance $50 r0 *1 57.63,1.77 nfet
X$50 BLB12__t0 WL0__t13 \$16__t4 VSS__t204 nfet_03v3 L=0.28U W=0.24U AS=0.1022P
+ AD=0.1684P PS=0.96U PD=1.72U
* device instance $51 r0 *1 55.59,1.83 nfet
X$51 VSS__t20 \$16__t2 \$105__t4 VSS__t268 nfet_03v3 L=0.28U W=0.36U AS=0.1022P
+ AD=0.169P PS=0.96U PD=1.28U
* device instance $52 r0 *1 56.77,1.83 nfet
X$52 \$16__t3 \$105__t2 VSS__t95 VSS__t332 nfet_03v3 L=0.28U W=0.36U AS=0.169P
+ AD=0.1022P PS=1.28U PD=0.96U
* device instance $53 r0 *1 59.19,1.77 nfet
X$53 \$108__t3 WL0__t108 BL13__t0 VSS__t141 nfet_03v3 L=0.28U W=0.24U
+ AS=0.1684P AD=0.1022P PS=1.72U PD=0.96U
* device instance $54 r0 *1 62.09,1.77 nfet
X$54 BLB13__t0 WL0__t22 \$17__t4 VSS__t205 nfet_03v3 L=0.28U W=0.24U AS=0.1022P
+ AD=0.1684P PS=0.96U PD=1.72U
* device instance $55 r0 *1 60.05,1.83 nfet
X$55 VSS__t24 \$17__t2 \$108__t4 VSS__t269 nfet_03v3 L=0.28U W=0.36U AS=0.1022P
+ AD=0.169P PS=0.96U PD=1.28U
* device instance $56 r0 *1 61.23,1.83 nfet
X$56 \$17__t3 \$108__t2 VSS__t90 VSS__t333 nfet_03v3 L=0.28U W=0.36U AS=0.169P
+ AD=0.1022P PS=1.28U PD=0.96U
* device instance $57 r0 *1 63.65,1.77 nfet
X$57 \$111__t3 WL0__t96 BL14__t0 VSS__t142 nfet_03v3 L=0.28U W=0.24U AS=0.1684P
+ AD=0.1022P PS=1.72U PD=0.96U
* device instance $58 r0 *1 66.55,1.77 nfet
X$58 BLB14__t0 WL0__t16 \$18__t4 VSS__t206 nfet_03v3 L=0.28U W=0.24U AS=0.1022P
+ AD=0.1684P PS=0.96U PD=1.72U
* device instance $59 r0 *1 64.51,1.83 nfet
X$59 VSS__t28 \$18__t2 \$111__t4 VSS__t270 nfet_03v3 L=0.28U W=0.36U AS=0.1022P
+ AD=0.169P PS=0.96U PD=1.28U
* device instance $60 r0 *1 65.69,1.83 nfet
X$60 \$18__t3 \$111__t2 VSS__t87 VSS__t334 nfet_03v3 L=0.28U W=0.36U AS=0.169P
+ AD=0.1022P PS=1.28U PD=0.96U
* device instance $61 r0 *1 68.11,1.77 nfet
X$61 \$114__t3 WL0__t93 BL15__t0 VSS__t143 nfet_03v3 L=0.28U W=0.24U AS=0.1684P
+ AD=0.1022P PS=1.72U PD=0.96U
* device instance $62 r0 *1 71.01,1.77 nfet
X$62 BLB15__t0 WL0__t3 \$19__t4 VSS__t207 nfet_03v3 L=0.28U W=0.24U AS=0.1022P
+ AD=0.1684P PS=0.96U PD=1.72U
* device instance $63 r0 *1 68.97,1.83 nfet
X$63 VSS__t31 \$19__t2 \$114__t4 VSS__t271 nfet_03v3 L=0.28U W=0.36U AS=0.1022P
+ AD=0.169P PS=0.96U PD=1.28U
* device instance $64 r0 *1 70.15,1.83 nfet
X$64 \$19__t3 \$114__t2 VSS__t83 VSS__t335 nfet_03v3 L=0.28U W=0.36U AS=0.169P
+ AD=0.1022P PS=1.28U PD=0.96U
* device instance $65 r0 *1 72.57,1.77 nfet
X$65 \$117__t3 WL0__t65 BL16__t0 VSS__t144 nfet_03v3 L=0.28U W=0.24U AS=0.1684P
+ AD=0.1022P PS=1.72U PD=0.96U
* device instance $66 r0 *1 75.47,1.77 nfet
X$66 BLB16__t0 WL0__t40 \$20__t4 VSS__t208 nfet_03v3 L=0.28U W=0.24U AS=0.1022P
+ AD=0.1684P PS=0.96U PD=1.72U
* device instance $67 r0 *1 73.43,1.83 nfet
X$67 VSS__t57 \$20__t2 \$117__t4 VSS__t272 nfet_03v3 L=0.28U W=0.36U AS=0.1022P
+ AD=0.169P PS=0.96U PD=1.28U
* device instance $68 r0 *1 74.61,1.83 nfet
X$68 \$20__t3 \$117__t2 VSS__t108 VSS__t336 nfet_03v3 L=0.28U W=0.36U AS=0.169P
+ AD=0.1022P PS=1.28U PD=0.96U
* device instance $69 r0 *1 77.03,1.77 nfet
X$69 \$120__t3 WL0__t74 BL17__t0 VSS__t145 nfet_03v3 L=0.28U W=0.24U AS=0.1684P
+ AD=0.1022P PS=1.72U PD=0.96U
* device instance $70 r0 *1 79.93,1.77 nfet
X$70 BLB17__t0 WL0__t38 \$21__t4 VSS__t209 nfet_03v3 L=0.28U W=0.24U AS=0.1022P
+ AD=0.1684P PS=0.96U PD=1.72U
* device instance $71 r0 *1 77.89,1.83 nfet
X$71 VSS__t63 \$21__t2 \$120__t4 VSS__t273 nfet_03v3 L=0.28U W=0.36U AS=0.1022P
+ AD=0.169P PS=0.96U PD=1.28U
* device instance $72 r0 *1 79.07,1.83 nfet
X$72 \$21__t3 \$120__t2 VSS__t106 VSS__t337 nfet_03v3 L=0.28U W=0.36U AS=0.169P
+ AD=0.1022P PS=1.28U PD=0.96U
* device instance $73 r0 *1 81.49,1.77 nfet
X$73 \$123__t3 WL0__t88 BL18__t0 VSS__t146 nfet_03v3 L=0.28U W=0.24U AS=0.1684P
+ AD=0.1022P PS=1.72U PD=0.96U
* device instance $74 r0 *1 84.39,1.77 nfet
X$74 BLB18__t0 WL0__t35 \$22__t4 VSS__t210 nfet_03v3 L=0.28U W=0.24U AS=0.1022P
+ AD=0.1684P PS=0.96U PD=1.72U
* device instance $75 r0 *1 82.35,1.83 nfet
X$75 VSS__t58 \$22__t2 \$123__t4 VSS__t274 nfet_03v3 L=0.28U W=0.36U AS=0.1022P
+ AD=0.169P PS=0.96U PD=1.28U
* device instance $76 r0 *1 83.53,1.83 nfet
X$76 \$22__t3 \$123__t2 VSS__t113 VSS__t338 nfet_03v3 L=0.28U W=0.36U AS=0.169P
+ AD=0.1022P PS=1.28U PD=0.96U
* device instance $77 r0 *1 85.95,1.77 nfet
X$77 \$126__t3 WL0__t78 BL19__t0 VSS__t147 nfet_03v3 L=0.28U W=0.24U AS=0.1684P
+ AD=0.1022P PS=1.72U PD=0.96U
* device instance $78 r0 *1 88.85,1.77 nfet
X$78 BLB19__t0 WL0__t31 \$23__t4 VSS__t211 nfet_03v3 L=0.28U W=0.24U AS=0.1022P
+ AD=0.1684P PS=0.96U PD=1.72U
* device instance $79 r0 *1 86.81,1.83 nfet
X$79 VSS__t55 \$23__t2 \$126__t4 VSS__t275 nfet_03v3 L=0.28U W=0.36U AS=0.1022P
+ AD=0.169P PS=0.96U PD=1.28U
* device instance $80 r0 *1 87.99,1.83 nfet
X$80 \$23__t3 \$126__t2 VSS__t119 VSS__t339 nfet_03v3 L=0.28U W=0.36U AS=0.169P
+ AD=0.1022P PS=1.28U PD=0.96U
* device instance $81 r0 *1 90.41,1.77 nfet
X$81 \$129__t3 WL0__t82 BL20__t0 VSS__t148 nfet_03v3 L=0.28U W=0.24U AS=0.1684P
+ AD=0.1022P PS=1.72U PD=0.96U
* device instance $82 r0 *1 93.31,1.77 nfet
X$82 BLB20__t0 WL0__t28 \$24__t4 VSS__t212 nfet_03v3 L=0.28U W=0.24U AS=0.1022P
+ AD=0.1684P PS=0.96U PD=1.72U
* device instance $83 r0 *1 91.27,1.83 nfet
X$83 VSS__t52 \$24__t2 \$129__t4 VSS__t276 nfet_03v3 L=0.28U W=0.36U AS=0.1022P
+ AD=0.169P PS=0.96U PD=1.28U
* device instance $84 r0 *1 92.45,1.83 nfet
X$84 \$24__t3 \$129__t2 VSS__t126 VSS__t340 nfet_03v3 L=0.28U W=0.36U AS=0.169P
+ AD=0.1022P PS=1.28U PD=0.96U
* device instance $85 r0 *1 94.87,1.77 nfet
X$85 \$132__t3 WL0__t85 BL21__t0 VSS__t149 nfet_03v3 L=0.28U W=0.24U AS=0.1684P
+ AD=0.1022P PS=1.72U PD=0.96U
* device instance $86 r0 *1 97.77,1.77 nfet
X$86 BLB21__t0 WL0__t25 \$25__t4 VSS__t213 nfet_03v3 L=0.28U W=0.24U AS=0.1022P
+ AD=0.1684P PS=0.96U PD=1.72U
* device instance $87 r0 *1 95.73,1.83 nfet
X$87 VSS__t3 \$25__t2 \$132__t4 VSS__t277 nfet_03v3 L=0.28U W=0.36U AS=0.1022P
+ AD=0.169P PS=0.96U PD=1.28U
* device instance $88 r0 *1 96.91,1.83 nfet
X$88 \$25__t3 \$132__t2 VSS__t127 VSS__t341 nfet_03v3 L=0.28U W=0.36U AS=0.169P
+ AD=0.1022P PS=1.28U PD=0.96U
* device instance $89 r0 *1 99.33,1.77 nfet
X$89 \$135__t3 WL0__t87 BL22__t0 VSS__t150 nfet_03v3 L=0.28U W=0.24U AS=0.1684P
+ AD=0.1022P PS=1.72U PD=0.96U
* device instance $90 r0 *1 102.23,1.77 nfet
X$90 BLB22__t0 WL0__t52 \$26__t4 VSS__t214 nfet_03v3 L=0.28U W=0.24U AS=0.1022P
+ AD=0.1684P PS=0.96U PD=1.72U
* device instance $91 r0 *1 100.19,1.83 nfet
X$91 VSS__t9 \$26__t2 \$135__t4 VSS__t278 nfet_03v3 L=0.28U W=0.36U AS=0.1022P
+ AD=0.169P PS=0.96U PD=1.28U
* device instance $92 r0 *1 101.37,1.83 nfet
X$92 \$26__t3 \$135__t2 VSS__t114 VSS__t342 nfet_03v3 L=0.28U W=0.36U AS=0.169P
+ AD=0.1022P PS=1.28U PD=0.96U
* device instance $93 r0 *1 103.79,1.77 nfet
X$93 \$138__t3 WL0__t84 BL23__t0 VSS__t151 nfet_03v3 L=0.28U W=0.24U AS=0.1684P
+ AD=0.1022P PS=1.72U PD=0.96U
* device instance $94 r0 *1 106.69,1.77 nfet
X$94 BLB23__t0 WL0__t57 \$27__t4 VSS__t215 nfet_03v3 L=0.28U W=0.24U AS=0.1022P
+ AD=0.1684P PS=0.96U PD=1.72U
* device instance $95 r0 *1 104.65,1.83 nfet
X$95 VSS__t4 \$27__t2 \$138__t4 VSS__t279 nfet_03v3 L=0.28U W=0.36U AS=0.1022P
+ AD=0.169P PS=0.96U PD=1.28U
* device instance $96 r0 *1 105.83,1.83 nfet
X$96 \$27__t3 \$138__t2 VSS__t107 VSS__t343 nfet_03v3 L=0.28U W=0.36U AS=0.169P
+ AD=0.1022P PS=1.28U PD=0.96U
* device instance $97 r0 *1 108.25,1.77 nfet
X$97 \$141__t3 WL0__t80 BL24__t0 VSS__t152 nfet_03v3 L=0.28U W=0.24U AS=0.1684P
+ AD=0.1022P PS=1.72U PD=0.96U
* device instance $98 r0 *1 111.15,1.77 nfet
X$98 BLB24__t0 WL0__t58 \$28__t4 VSS__t216 nfet_03v3 L=0.28U W=0.24U AS=0.1022P
+ AD=0.1684P PS=0.96U PD=1.72U
* device instance $99 r0 *1 109.11,1.83 nfet
X$99 VSS__t29 \$28__t2 \$141__t4 VSS__t280 nfet_03v3 L=0.28U W=0.36U AS=0.1022P
+ AD=0.169P PS=0.96U PD=1.28U
* device instance $100 r0 *1 110.29,1.83 nfet
X$100 \$28__t3 \$141__t2 VSS__t105 VSS__t344 nfet_03v3 L=0.28U W=0.36U
+ AS=0.169P AD=0.1022P PS=1.28U PD=0.96U
* device instance $101 r0 *1 112.71,1.77 nfet
X$101 \$144__t3 WL0__t77 BL25__t0 VSS__t153 nfet_03v3 L=0.28U W=0.24U
+ AS=0.1684P AD=0.1022P PS=1.72U PD=0.96U
* device instance $102 r0 *1 115.61,1.77 nfet
X$102 BLB25__t0 WL0__t61 \$29__t4 VSS__t217 nfet_03v3 L=0.28U W=0.24U
+ AS=0.1022P AD=0.1684P PS=0.96U PD=1.72U
* device instance $103 r0 *1 113.57,1.83 nfet
X$103 VSS__t25 \$29__t2 \$144__t4 VSS__t281 nfet_03v3 L=0.28U W=0.36U
+ AS=0.1022P AD=0.169P PS=0.96U PD=1.28U
* device instance $104 r0 *1 114.75,1.83 nfet
X$104 \$29__t3 \$144__t2 VSS__t112 VSS__t345 nfet_03v3 L=0.28U W=0.36U
+ AS=0.169P AD=0.1022P PS=1.28U PD=0.96U
* device instance $105 r0 *1 117.17,1.77 nfet
X$105 \$147__t3 WL0__t66 BL26__t0 VSS__t154 nfet_03v3 L=0.28U W=0.24U
+ AS=0.1684P AD=0.1022P PS=1.72U PD=0.96U
* device instance $106 r0 *1 120.07,1.77 nfet
X$106 BLB26__t0 WL0__t64 \$30__t4 VSS__t218 nfet_03v3 L=0.28U W=0.24U
+ AS=0.1022P AD=0.1684P PS=0.96U PD=1.72U
* device instance $107 r0 *1 118.03,1.83 nfet
X$107 VSS__t19 \$30__t2 \$147__t4 VSS__t282 nfet_03v3 L=0.28U W=0.36U
+ AS=0.1022P AD=0.169P PS=0.96U PD=1.28U
* device instance $108 r0 *1 119.21,1.83 nfet
X$108 \$30__t3 \$147__t2 VSS__t116 VSS__t346 nfet_03v3 L=0.28U W=0.36U
+ AS=0.169P AD=0.1022P PS=1.28U PD=0.96U
* device instance $109 r0 *1 121.63,1.77 nfet
X$109 \$150__t3 WL0__t70 BL27__t0 VSS__t155 nfet_03v3 L=0.28U W=0.24U
+ AS=0.1684P AD=0.1022P PS=1.72U PD=0.96U
* device instance $110 r0 *1 124.53,1.77 nfet
X$110 BLB27__t0 WL0__t50 \$31__t4 VSS__t219 nfet_03v3 L=0.28U W=0.24U
+ AS=0.1022P AD=0.1684P PS=0.96U PD=1.72U
* device instance $111 r0 *1 122.49,1.83 nfet
X$111 VSS__t12 \$31__t2 \$150__t4 VSS__t283 nfet_03v3 L=0.28U W=0.36U
+ AS=0.1022P AD=0.169P PS=0.96U PD=1.28U
* device instance $112 r0 *1 123.67,1.83 nfet
X$112 \$31__t3 \$150__t2 VSS__t123 VSS__t347 nfet_03v3 L=0.28U W=0.36U
+ AS=0.169P AD=0.1022P PS=1.28U PD=0.96U
* device instance $113 r0 *1 126.09,1.77 nfet
X$113 \$153__t3 WL0__t98 BL28__t0 VSS__t156 nfet_03v3 L=0.28U W=0.24U
+ AS=0.1684P AD=0.1022P PS=1.72U PD=0.96U
* device instance $114 r0 *1 128.99,1.77 nfet
X$114 BLB28__t0 WL0__t43 \$32__t4 VSS__t220 nfet_03v3 L=0.28U W=0.24U
+ AS=0.1022P AD=0.1684P PS=0.96U PD=1.72U
* device instance $115 r0 *1 126.95,1.83 nfet
X$115 VSS__t42 \$32__t2 \$153__t4 VSS__t284 nfet_03v3 L=0.28U W=0.36U
+ AS=0.1022P AD=0.169P PS=0.96U PD=1.28U
* device instance $116 r0 *1 128.13,1.83 nfet
X$116 \$32__t3 \$153__t2 VSS__t117 VSS__t348 nfet_03v3 L=0.28U W=0.36U
+ AS=0.169P AD=0.1022P PS=1.28U PD=0.96U
* device instance $117 r0 *1 130.55,1.77 nfet
X$117 \$156__t3 WL0__t73 BL29__t0 VSS__t157 nfet_03v3 L=0.28U W=0.24U
+ AS=0.1684P AD=0.1022P PS=1.72U PD=0.96U
* device instance $118 r0 *1 133.45,1.77 nfet
X$118 BLB29__t0 WL0__t45 \$33__t4 VSS__t221 nfet_03v3 L=0.28U W=0.24U
+ AS=0.1022P AD=0.1684P PS=0.96U PD=1.72U
* device instance $119 r0 *1 131.41,1.83 nfet
X$119 VSS__t45 \$33__t2 \$156__t4 VSS__t285 nfet_03v3 L=0.28U W=0.36U
+ AS=0.1022P AD=0.169P PS=0.96U PD=1.28U
* device instance $120 r0 *1 132.59,1.83 nfet
X$120 \$33__t3 \$156__t2 VSS__t124 VSS__t349 nfet_03v3 L=0.28U W=0.36U
+ AS=0.169P AD=0.1022P PS=1.28U PD=0.96U
* device instance $121 r0 *1 135.01,1.77 nfet
X$121 \$159__t3 WL0__t71 BL30__t0 VSS__t158 nfet_03v3 L=0.28U W=0.24U
+ AS=0.1684P AD=0.1022P PS=1.72U PD=0.96U
* device instance $122 r0 *1 137.91,1.77 nfet
X$122 BLB30__t0 WL0__t47 \$34__t4 VSS__t222 nfet_03v3 L=0.28U W=0.24U
+ AS=0.1022P AD=0.1684P PS=0.96U PD=1.72U
* device instance $123 r0 *1 135.87,1.83 nfet
X$123 VSS__t48 \$34__t2 \$159__t4 VSS__t286 nfet_03v3 L=0.28U W=0.36U
+ AS=0.1022P AD=0.169P PS=0.96U PD=1.28U
* device instance $124 r0 *1 137.05,1.83 nfet
X$124 \$34__t3 \$159__t2 VSS__t81 VSS__t350 nfet_03v3 L=0.28U W=0.36U AS=0.169P
+ AD=0.1022P PS=1.28U PD=0.96U
* device instance $125 r0 *1 139.47,1.77 nfet
X$125 \$162__t3 WL0__t109 BL31__t0 VSS__t159 nfet_03v3 L=0.28U W=0.24U
+ AS=0.1684P AD=0.1022P PS=1.72U PD=0.96U
* device instance $126 r0 *1 142.37,1.77 nfet
X$126 BLB31__t0 WL0__t46 \$35__t4 VSS__t223 nfet_03v3 L=0.28U W=0.24U
+ AS=0.1022P AD=0.1684P PS=0.96U PD=1.72U
* device instance $127 r0 *1 140.33,1.83 nfet
X$127 VSS__t46 \$35__t2 \$162__t4 VSS__t287 nfet_03v3 L=0.28U W=0.36U
+ AS=0.1022P AD=0.169P PS=0.96U PD=1.28U
* device instance $128 r0 *1 141.51,1.83 nfet
X$128 \$35__t3 \$162__t2 VSS__t80 VSS__t351 nfet_03v3 L=0.28U W=0.36U AS=0.169P
+ AD=0.1022P PS=1.28U PD=0.96U
* device instance $129 r0 *1 143.93,1.77 nfet
X$129 \$165__t3 WL0 BL32__t0 VSS__t160 nfet_03v3 L=0.28U W=0.24U AS=0.1684P
+ AD=0.1022P PS=1.72U PD=0.96U
* device instance $130 r0 *1 146.83,1.77 nfet
X$130 BLB32__t0 WL0__t29 \$36__t4 VSS__t224 nfet_03v3 L=0.28U W=0.24U
+ AS=0.1022P AD=0.1684P PS=0.96U PD=1.72U
* device instance $131 r0 *1 144.79,1.83 nfet
X$131 VSS__t51 \$36__t2 \$165__t4 VSS__t288 nfet_03v3 L=0.28U W=0.36U
+ AS=0.1022P AD=0.169P PS=0.96U PD=1.28U
* device instance $132 r0 *1 145.97,1.83 nfet
X$132 \$36__t3 \$165__t2 VSS__t96 VSS__t352 nfet_03v3 L=0.28U W=0.36U AS=0.169P
+ AD=0.1022P PS=1.28U PD=0.96U
* device instance $133 r0 *1 148.39,1.77 nfet
X$133 \$168__t3 WL0__t125 BL33__t0 VSS__t161 nfet_03v3 L=0.28U W=0.24U
+ AS=0.1684P AD=0.1022P PS=1.72U PD=0.96U
* device instance $134 r0 *1 151.29,1.77 nfet
X$134 BLB33__t0 WL0__t30 \$37__t4 VSS__t225 nfet_03v3 L=0.28U W=0.24U
+ AS=0.1022P AD=0.1684P PS=0.96U PD=1.72U
* device instance $135 r0 *1 149.25,1.83 nfet
X$135 VSS__t53 \$37__t2 \$168__t4 VSS__t289 nfet_03v3 L=0.28U W=0.36U
+ AS=0.1022P AD=0.169P PS=0.96U PD=1.28U
* device instance $136 r0 *1 150.43,1.83 nfet
X$136 \$37__t3 \$168__t2 VSS__t99 VSS__t353 nfet_03v3 L=0.28U W=0.36U AS=0.169P
+ AD=0.1022P PS=1.28U PD=0.96U
* device instance $137 r0 *1 152.85,1.77 nfet
X$137 \$171__t3 WL0__t124 BL34__t0 VSS__t162 nfet_03v3 L=0.28U W=0.24U
+ AS=0.1684P AD=0.1022P PS=1.72U PD=0.96U
* device instance $138 r0 *1 155.75,1.77 nfet
X$138 BLB34__t0 WL0__t32 \$38__t4 VSS__t226 nfet_03v3 L=0.28U W=0.24U
+ AS=0.1022P AD=0.1684P PS=0.96U PD=1.72U
* device instance $139 r0 *1 153.71,1.83 nfet
X$139 VSS__t56 \$38__t2 \$171__t4 VSS__t290 nfet_03v3 L=0.28U W=0.36U
+ AS=0.1022P AD=0.169P PS=0.96U PD=1.28U
* device instance $140 r0 *1 154.89,1.83 nfet
X$140 \$38__t3 \$171__t2 VSS__t102 VSS__t354 nfet_03v3 L=0.28U W=0.36U
+ AS=0.169P AD=0.1022P PS=1.28U PD=0.96U
* device instance $141 r0 *1 157.31,1.77 nfet
X$141 \$174__t3 WL0__t123 BL35__t0 VSS__t163 nfet_03v3 L=0.28U W=0.24U
+ AS=0.1684P AD=0.1022P PS=1.72U PD=0.96U
* device instance $142 r0 *1 160.21,1.77 nfet
X$142 BLB35__t0 WL0__t33 \$39__t4 VSS__t227 nfet_03v3 L=0.28U W=0.24U
+ AS=0.1022P AD=0.1684P PS=0.96U PD=1.72U
* device instance $143 r0 *1 158.17,1.83 nfet
X$143 VSS__t62 \$39__t2 \$174__t4 VSS__t291 nfet_03v3 L=0.28U W=0.36U
+ AS=0.1022P AD=0.169P PS=0.96U PD=1.28U
* device instance $144 r0 *1 159.35,1.83 nfet
X$144 \$39__t3 \$174__t2 VSS__t66 VSS__t355 nfet_03v3 L=0.28U W=0.36U AS=0.169P
+ AD=0.1022P PS=1.28U PD=0.96U
* device instance $145 r0 *1 161.77,1.77 nfet
X$145 \$177__t3 WL0__t122 BL36__t0 VSS__t164 nfet_03v3 L=0.28U W=0.24U
+ AS=0.1684P AD=0.1022P PS=1.72U PD=0.96U
* device instance $146 r0 *1 164.67,1.77 nfet
X$146 BLB36__t0 WL0__t34 \$40__t4 VSS__t228 nfet_03v3 L=0.28U W=0.24U
+ AS=0.1022P AD=0.1684P PS=0.96U PD=1.72U
* device instance $147 r0 *1 162.63,1.83 nfet
X$147 VSS__t60 \$40__t2 \$177__t4 VSS__t292 nfet_03v3 L=0.28U W=0.36U
+ AS=0.1022P AD=0.169P PS=0.96U PD=1.28U
* device instance $148 r0 *1 163.81,1.83 nfet
X$148 \$40__t3 \$177__t2 VSS__t69 VSS__t356 nfet_03v3 L=0.28U W=0.36U AS=0.169P
+ AD=0.1022P PS=1.28U PD=0.96U
* device instance $149 r0 *1 166.23,1.77 nfet
X$149 \$180__t3 WL0__t121 BL37__t0 VSS__t165 nfet_03v3 L=0.28U W=0.24U
+ AS=0.1684P AD=0.1022P PS=1.72U PD=0.96U
* device instance $150 r0 *1 169.13,1.77 nfet
X$150 BLB37__t0 WL0__t48 \$41__t4 VSS__t229 nfet_03v3 L=0.28U W=0.24U
+ AS=0.1022P AD=0.1684P PS=0.96U PD=1.72U
* device instance $151 r0 *1 167.09,1.83 nfet
X$151 VSS__t64 \$41__t2 \$180__t4 VSS__t293 nfet_03v3 L=0.28U W=0.36U
+ AS=0.1022P AD=0.169P PS=0.96U PD=1.28U
* device instance $152 r0 *1 168.27,1.83 nfet
X$152 \$41__t3 \$180__t2 VSS__t70 VSS__t357 nfet_03v3 L=0.28U W=0.36U AS=0.169P
+ AD=0.1022P PS=1.28U PD=0.96U
* device instance $153 r0 *1 170.69,1.77 nfet
X$153 \$183__t3 WL0__t119 BL38__t0 VSS__t166 nfet_03v3 L=0.28U W=0.24U
+ AS=0.1684P AD=0.1022P PS=1.72U PD=0.96U
* device instance $154 r0 *1 173.59,1.77 nfet
X$154 BLB38__t0 WL0__t37 \$42__t4 VSS__t230 nfet_03v3 L=0.28U W=0.24U
+ AS=0.1022P AD=0.1684P PS=0.96U PD=1.72U
* device instance $155 r0 *1 171.55,1.83 nfet
X$155 VSS__t33 \$42__t2 \$183__t4 VSS__t294 nfet_03v3 L=0.28U W=0.36U
+ AS=0.1022P AD=0.169P PS=0.96U PD=1.28U
* device instance $156 r0 *1 172.73,1.83 nfet
X$156 \$42__t3 \$183__t2 VSS__t72 VSS__t358 nfet_03v3 L=0.28U W=0.36U AS=0.169P
+ AD=0.1022P PS=1.28U PD=0.96U
* device instance $157 r0 *1 175.15,1.77 nfet
X$157 \$186__t3 WL0__t118 BL39__t0 VSS__t167 nfet_03v3 L=0.28U W=0.24U
+ AS=0.1684P AD=0.1022P PS=1.72U PD=0.96U
* device instance $158 r0 *1 178.05,1.77 nfet
X$158 BLB39__t0 WL0__t39 \$43__t4 VSS__t231 nfet_03v3 L=0.28U W=0.24U
+ AS=0.1022P AD=0.1684P PS=0.96U PD=1.72U
* device instance $159 r0 *1 176.01,1.83 nfet
X$159 VSS__t35 \$43__t2 \$186__t4 VSS__t295 nfet_03v3 L=0.28U W=0.36U
+ AS=0.1022P AD=0.169P PS=0.96U PD=1.28U
* device instance $160 r0 *1 177.19,1.83 nfet
X$160 \$43__t3 \$186__t2 VSS__t82 VSS__t359 nfet_03v3 L=0.28U W=0.36U AS=0.169P
+ AD=0.1022P PS=1.28U PD=0.96U
* device instance $161 r0 *1 179.61,1.77 nfet
X$161 \$189__t3 WL0__t101 BL40__t0 VSS__t168 nfet_03v3 L=0.28U W=0.24U
+ AS=0.1684P AD=0.1022P PS=1.72U PD=0.96U
* device instance $162 r0 *1 182.51,1.77 nfet
X$162 BLB40__t0 WL0__t12 \$44__t4 VSS__t232 nfet_03v3 L=0.28U W=0.24U
+ AS=0.1022P AD=0.1684P PS=0.96U PD=1.72U
* device instance $163 r0 *1 180.47,1.83 nfet
X$163 VSS__t16 \$44__t2 \$189__t4 VSS__t296 nfet_03v3 L=0.28U W=0.36U
+ AS=0.1022P AD=0.169P PS=0.96U PD=1.28U
* device instance $164 r0 *1 181.65,1.83 nfet
X$164 \$44__t3 \$189__t2 VSS__t100 VSS__t360 nfet_03v3 L=0.28U W=0.36U
+ AS=0.169P AD=0.1022P PS=1.28U PD=0.96U
* device instance $165 r0 *1 184.07,1.77 nfet
X$165 \$192__t3 WL0__t104 BL41__t0 VSS__t169 nfet_03v3 L=0.28U W=0.24U
+ AS=0.1684P AD=0.1022P PS=1.72U PD=0.96U
* device instance $166 r0 *1 186.97,1.77 nfet
X$166 BLB41__t0 WL0__t6 \$45__t4 VSS__t233 nfet_03v3 L=0.28U W=0.24U AS=0.1022P
+ AD=0.1684P PS=0.96U PD=1.72U
* device instance $167 r0 *1 184.93,1.83 nfet
X$167 VSS__t13 \$45__t2 \$192__t4 VSS__t297 nfet_03v3 L=0.28U W=0.36U
+ AS=0.1022P AD=0.169P PS=0.96U PD=1.28U
* device instance $168 r0 *1 186.11,1.83 nfet
X$168 \$45__t3 \$192__t2 VSS__t65 VSS__t361 nfet_03v3 L=0.28U W=0.36U AS=0.169P
+ AD=0.1022P PS=1.28U PD=0.96U
* device instance $169 r0 *1 188.53,1.77 nfet
X$169 \$195__t3 WL0__t106 BL42__t0 VSS__t170 nfet_03v3 L=0.28U W=0.24U
+ AS=0.1684P AD=0.1022P PS=1.72U PD=0.96U
* device instance $170 r0 *1 191.43,1.77 nfet
X$170 BLB42__t0 WL0__t2 \$46__t4 VSS__t234 nfet_03v3 L=0.28U W=0.24U AS=0.1022P
+ AD=0.1684P PS=0.96U PD=1.72U
* device instance $171 r0 *1 189.39,1.83 nfet
X$171 VSS__t36 \$46__t2 \$195__t4 VSS__t298 nfet_03v3 L=0.28U W=0.36U
+ AS=0.1022P AD=0.169P PS=0.96U PD=1.28U
* device instance $172 r0 *1 190.57,1.83 nfet
X$172 \$46__t3 \$195__t2 VSS__t118 VSS__t362 nfet_03v3 L=0.28U W=0.36U
+ AS=0.169P AD=0.1022P PS=1.28U PD=0.96U
* device instance $173 r0 *1 192.99,1.77 nfet
X$173 \$198__t3 WL0__t107 BL43__t0 VSS__t171 nfet_03v3 L=0.28U W=0.24U
+ AS=0.1684P AD=0.1022P PS=1.72U PD=0.96U
* device instance $174 r0 *1 195.89,1.77 nfet
X$174 BLB43__t0 WL0__t54 \$47__t4 VSS__t235 nfet_03v3 L=0.28U W=0.24U
+ AS=0.1022P AD=0.1684P PS=0.96U PD=1.72U
* device instance $175 r0 *1 193.85,1.83 nfet
X$175 VSS__t11 \$47__t2 \$198__t4 VSS__t299 nfet_03v3 L=0.28U W=0.36U
+ AS=0.1022P AD=0.169P PS=0.96U PD=1.28U
* device instance $176 r0 *1 195.03,1.83 nfet
X$176 \$47__t3 \$198__t2 VSS__t92 VSS__t363 nfet_03v3 L=0.28U W=0.36U AS=0.169P
+ AD=0.1022P PS=1.28U PD=0.96U
* device instance $177 r0 *1 197.45,1.77 nfet
X$177 \$201__t3 WL0__t105 BL44__t0 VSS__t172 nfet_03v3 L=0.28U W=0.24U
+ AS=0.1684P AD=0.1022P PS=1.72U PD=0.96U
* device instance $178 r0 *1 200.35,1.77 nfet
X$178 BLB44__t0 WL0__t59 \$48__t4 VSS__t236 nfet_03v3 L=0.28U W=0.24U
+ AS=0.1022P AD=0.1684P PS=0.96U PD=1.72U
* device instance $179 r0 *1 198.31,1.83 nfet
X$179 VSS__t14 \$48__t2 \$201__t4 VSS__t300 nfet_03v3 L=0.28U W=0.36U
+ AS=0.1022P AD=0.169P PS=0.96U PD=1.28U
* device instance $180 r0 *1 199.49,1.83 nfet
X$180 \$48__t3 \$201__t2 VSS__t101 VSS__t364 nfet_03v3 L=0.28U W=0.36U
+ AS=0.169P AD=0.1022P PS=1.28U PD=0.96U
* device instance $181 r0 *1 201.91,1.77 nfet
X$181 \$204__t3 WL0__t103 BL45__t0 VSS__t173 nfet_03v3 L=0.28U W=0.24U
+ AS=0.1684P AD=0.1022P PS=1.72U PD=0.96U
* device instance $182 r0 *1 204.81,1.77 nfet
X$182 BLB45__t0 WL0__t53 \$49__t4 VSS__t237 nfet_03v3 L=0.28U W=0.24U
+ AS=0.1022P AD=0.1684P PS=0.96U PD=1.72U
* device instance $183 r0 *1 202.77,1.83 nfet
X$183 VSS__t17 \$49__t2 \$204__t4 VSS__t301 nfet_03v3 L=0.28U W=0.36U
+ AS=0.1022P AD=0.169P PS=0.96U PD=1.28U
* device instance $184 r0 *1 203.95,1.83 nfet
X$184 \$49__t3 \$204__t2 VSS__t98 VSS__t365 nfet_03v3 L=0.28U W=0.36U AS=0.169P
+ AD=0.1022P PS=1.28U PD=0.96U
* device instance $185 r0 *1 206.37,1.77 nfet
X$185 \$207__t3 WL0__t102 BL46__t0 VSS__t174 nfet_03v3 L=0.28U W=0.24U
+ AS=0.1684P AD=0.1022P PS=1.72U PD=0.96U
* device instance $186 r0 *1 209.27,1.77 nfet
X$186 BLB46__t0 WL0__t55 \$50__t4 VSS__t238 nfet_03v3 L=0.28U W=0.24U
+ AS=0.1022P AD=0.1684P PS=0.96U PD=1.72U
* device instance $187 r0 *1 207.23,1.83 nfet
X$187 VSS__t18 \$50__t2 \$207__t4 VSS__t302 nfet_03v3 L=0.28U W=0.36U
+ AS=0.1022P AD=0.169P PS=0.96U PD=1.28U
* device instance $188 r0 *1 208.41,1.83 nfet
X$188 \$50__t3 \$207__t2 VSS__t97 VSS__t366 nfet_03v3 L=0.28U W=0.36U AS=0.169P
+ AD=0.1022P PS=1.28U PD=0.96U
* device instance $189 r0 *1 210.83,1.77 nfet
X$189 \$210__t3 WL0__t99 BL47__t0 VSS__t175 nfet_03v3 L=0.28U W=0.24U
+ AS=0.1684P AD=0.1022P PS=1.72U PD=0.96U
* device instance $190 r0 *1 213.73,1.77 nfet
X$190 BLB47__t0 WL0__t49 \$51__t4 VSS__t239 nfet_03v3 L=0.28U W=0.24U
+ AS=0.1022P AD=0.1684P PS=0.96U PD=1.72U
* device instance $191 r0 *1 211.69,1.83 nfet
X$191 VSS__t32 \$51__t2 \$210__t4 VSS__t303 nfet_03v3 L=0.28U W=0.36U
+ AS=0.1022P AD=0.169P PS=0.96U PD=1.28U
* device instance $192 r0 *1 212.87,1.83 nfet
X$192 \$51__t3 \$210__t2 VSS__t94 VSS__t367 nfet_03v3 L=0.28U W=0.36U AS=0.169P
+ AD=0.1022P PS=1.28U PD=0.96U
* device instance $193 r0 *1 215.29,1.77 nfet
X$193 \$213__t3 WL0__t116 BL48__t0 VSS__t176 nfet_03v3 L=0.28U W=0.24U
+ AS=0.1684P AD=0.1022P PS=1.72U PD=0.96U
* device instance $194 r0 *1 218.19,1.77 nfet
X$194 BLB48__t0 WL0__t62 \$52__t4 VSS__t240 nfet_03v3 L=0.28U W=0.24U
+ AS=0.1022P AD=0.1684P PS=0.96U PD=1.72U
* device instance $195 r0 *1 216.15,1.83 nfet
X$195 VSS__t15 \$52__t2 \$213__t4 VSS__t304 nfet_03v3 L=0.28U W=0.36U
+ AS=0.1022P AD=0.169P PS=0.96U PD=1.28U
* device instance $196 r0 *1 217.33,1.83 nfet
X$196 \$52__t3 \$213__t2 VSS__t122 VSS__t368 nfet_03v3 L=0.28U W=0.36U
+ AS=0.169P AD=0.1022P PS=1.28U PD=0.96U
* device instance $197 r0 *1 219.75,1.77 nfet
X$197 \$216__t3 WL0__t68 BL49__t0 VSS__t177 nfet_03v3 L=0.28U W=0.24U
+ AS=0.1684P AD=0.1022P PS=1.72U PD=0.96U
* device instance $198 r0 *1 222.65,1.77 nfet
X$198 BLB49__t0 WL0__t17 \$53__t4 VSS__t241 nfet_03v3 L=0.28U W=0.24U
+ AS=0.1022P AD=0.1684P PS=0.96U PD=1.72U
* device instance $199 r0 *1 220.61,1.83 nfet
X$199 VSS__t22 \$53__t2 \$216__t4 VSS__t305 nfet_03v3 L=0.28U W=0.36U
+ AS=0.1022P AD=0.169P PS=0.96U PD=1.28U
* device instance $200 r0 *1 221.79,1.83 nfet
X$200 \$53__t3 \$216__t2 VSS__t109 VSS__t369 nfet_03v3 L=0.28U W=0.36U
+ AS=0.169P AD=0.1022P PS=1.28U PD=0.96U
* device instance $201 r0 *1 224.21,1.77 nfet
X$201 \$219__t3 WL0__t75 BL50__t0 VSS__t178 nfet_03v3 L=0.28U W=0.24U
+ AS=0.1684P AD=0.1022P PS=1.72U PD=0.96U
* device instance $202 r0 *1 227.11,1.77 nfet
X$202 BLB50__t0 WL0__t11 \$54__t4 VSS__t242 nfet_03v3 L=0.28U W=0.24U
+ AS=0.1022P AD=0.1684P PS=0.96U PD=1.72U
* device instance $203 r0 *1 225.07,1.83 nfet
X$203 VSS__t2 \$54__t2 \$219__t4 VSS__t306 nfet_03v3 L=0.28U W=0.36U AS=0.1022P
+ AD=0.169P PS=0.96U PD=1.28U
* device instance $204 r0 *1 226.25,1.83 nfet
X$204 \$54__t3 \$219__t2 VSS__t104 VSS__t370 nfet_03v3 L=0.28U W=0.36U
+ AS=0.169P AD=0.1022P PS=1.28U PD=0.96U
* device instance $205 r0 *1 228.67,1.77 nfet
X$205 \$222__t3 WL0__t81 BL51__t0 VSS__t179 nfet_03v3 L=0.28U W=0.24U
+ AS=0.1684P AD=0.1022P PS=1.72U PD=0.96U
* device instance $206 r0 *1 231.57,1.77 nfet
X$206 BLB51__t0 WL0__t18 \$55__t4 VSS__t243 nfet_03v3 L=0.28U W=0.24U
+ AS=0.1022P AD=0.1684P PS=0.96U PD=1.72U
* device instance $207 r0 *1 229.53,1.83 nfet
X$207 VSS__t7 \$55__t2 \$222__t4 VSS__t307 nfet_03v3 L=0.28U W=0.36U AS=0.1022P
+ AD=0.169P PS=0.96U PD=1.28U
* device instance $208 r0 *1 230.71,1.83 nfet
X$208 \$55__t3 \$222__t2 VSS__t121 VSS__t371 nfet_03v3 L=0.28U W=0.36U
+ AS=0.169P AD=0.1022P PS=1.28U PD=0.96U
* device instance $209 r0 *1 233.13,1.77 nfet
X$209 \$225__t3 WL0__t86 BL52__t0 VSS__t180 nfet_03v3 L=0.28U W=0.24U
+ AS=0.1684P AD=0.1022P PS=1.72U PD=0.96U
* device instance $210 r0 *1 236.03,1.77 nfet
X$210 BLB52__t0 WL0__t7 \$56__t4 VSS__t244 nfet_03v3 L=0.28U W=0.24U AS=0.1022P
+ AD=0.1684P PS=0.96U PD=1.72U
* device instance $211 r0 *1 233.99,1.83 nfet
X$211 VSS__t21 \$56__t2 \$225__t4 VSS__t308 nfet_03v3 L=0.28U W=0.36U
+ AS=0.1022P AD=0.169P PS=0.96U PD=1.28U
* device instance $212 r0 *1 235.17,1.83 nfet
X$212 \$56__t3 \$225__t2 VSS__t125 VSS__t372 nfet_03v3 L=0.28U W=0.36U
+ AS=0.169P AD=0.1022P PS=1.28U PD=0.96U
* device instance $213 r0 *1 237.59,1.77 nfet
X$213 \$228__t3 WL0__t83 BL53__t0 VSS__t181 nfet_03v3 L=0.28U W=0.24U
+ AS=0.1684P AD=0.1022P PS=1.72U PD=0.96U
* device instance $214 r0 *1 240.49,1.77 nfet
X$214 BLB53__t0 WL0__t5 \$57__t4 VSS__t245 nfet_03v3 L=0.28U W=0.24U AS=0.1022P
+ AD=0.1684P PS=0.96U PD=1.72U
* device instance $215 r0 *1 238.45,1.83 nfet
X$215 VSS__t54 \$57__t2 \$228__t4 VSS__t309 nfet_03v3 L=0.28U W=0.36U
+ AS=0.1022P AD=0.169P PS=0.96U PD=1.28U
* device instance $216 r0 *1 239.63,1.83 nfet
X$216 \$57__t3 \$228__t2 VSS__t115 VSS__t373 nfet_03v3 L=0.28U W=0.36U
+ AS=0.169P AD=0.1022P PS=1.28U PD=0.96U
* device instance $217 r0 *1 242.05,1.77 nfet
X$217 \$231__t3 WL0__t79 BL54__t0 VSS__t182 nfet_03v3 L=0.28U W=0.24U
+ AS=0.1684P AD=0.1022P PS=1.72U PD=0.96U
* device instance $218 r0 *1 244.95,1.77 nfet
X$218 BLB54__t0 WL0__t14 \$58__t4 VSS__t246 nfet_03v3 L=0.28U W=0.24U
+ AS=0.1022P AD=0.1684P PS=0.96U PD=1.72U
* device instance $219 r0 *1 242.91,1.83 nfet
X$219 VSS__t59 \$58__t2 \$231__t4 VSS__t310 nfet_03v3 L=0.28U W=0.36U
+ AS=0.1022P AD=0.169P PS=0.96U PD=1.28U
* device instance $220 r0 *1 244.09,1.83 nfet
X$220 \$58__t3 \$231__t2 VSS__t110 VSS__t374 nfet_03v3 L=0.28U W=0.36U
+ AS=0.169P AD=0.1022P PS=1.28U PD=0.96U
* device instance $221 r0 *1 246.51,1.77 nfet
X$221 \$234__t3 WL0__t76 BL55__t0 VSS__t183 nfet_03v3 L=0.28U W=0.24U
+ AS=0.1684P AD=0.1022P PS=1.72U PD=0.96U
* device instance $222 r0 *1 249.41,1.77 nfet
X$222 BLB55__t0 WL0__t23 \$59__t4 VSS__t247 nfet_03v3 L=0.28U W=0.24U
+ AS=0.1022P AD=0.1684P PS=0.96U PD=1.72U
* device instance $223 r0 *1 247.37,1.83 nfet
X$223 VSS__t34 \$59__t2 \$234__t4 VSS__t311 nfet_03v3 L=0.28U W=0.36U
+ AS=0.1022P AD=0.169P PS=0.96U PD=1.28U
* device instance $224 r0 *1 248.55,1.83 nfet
X$224 \$59__t3 \$234__t2 VSS__t111 VSS__t375 nfet_03v3 L=0.28U W=0.36U
+ AS=0.169P AD=0.1022P PS=1.28U PD=0.96U
* device instance $225 r0 *1 250.97,1.77 nfet
X$225 \$237__t3 WL0__t67 BL56__t0 VSS__t184 nfet_03v3 L=0.28U W=0.24U
+ AS=0.1684P AD=0.1022P PS=1.72U PD=0.96U
* device instance $226 r0 *1 253.87,1.77 nfet
X$226 BLB56__t0 WL0__t20 \$60__t4 VSS__t248 nfet_03v3 L=0.28U W=0.24U
+ AS=0.1022P AD=0.1684P PS=0.96U PD=1.72U
* device instance $227 r0 *1 251.83,1.83 nfet
X$227 VSS__t39 \$60__t2 \$237__t4 VSS__t312 nfet_03v3 L=0.28U W=0.36U
+ AS=0.1022P AD=0.169P PS=0.96U PD=1.28U
* device instance $228 r0 *1 253.01,1.83 nfet
X$228 \$60__t3 \$237__t2 VSS__t120 VSS__t376 nfet_03v3 L=0.28U W=0.36U
+ AS=0.169P AD=0.1022P PS=1.28U PD=0.96U
* device instance $229 r0 *1 255.43,1.77 nfet
X$229 \$240__t3 WL0__t69 BL57__t0 VSS__t185 nfet_03v3 L=0.28U W=0.24U
+ AS=0.1684P AD=0.1022P PS=1.72U PD=0.96U
* device instance $230 r0 *1 258.33,1.77 nfet
X$230 BLB57__t0 WL0__t8 \$61__t4 VSS__t249 nfet_03v3 L=0.28U W=0.24U AS=0.1022P
+ AD=0.1684P PS=0.96U PD=1.72U
* device instance $231 r0 *1 256.29,1.83 nfet
X$231 VSS__t49 \$61__t2 \$240__t4 VSS__t313 nfet_03v3 L=0.28U W=0.36U
+ AS=0.1022P AD=0.169P PS=0.96U PD=1.28U
* device instance $232 r0 *1 257.47,1.83 nfet
X$232 \$61__t3 \$240__t2 VSS__t67 VSS__t377 nfet_03v3 L=0.28U W=0.36U AS=0.169P
+ AD=0.1022P PS=1.28U PD=0.96U
* device instance $233 r0 *1 259.89,1.77 nfet
X$233 \$243__t3 WL0__t72 BL58__t0 VSS__t186 nfet_03v3 L=0.28U W=0.24U
+ AS=0.1684P AD=0.1022P PS=1.72U PD=0.96U
* device instance $234 r0 *1 262.79,1.77 nfet
X$234 BLB58__t0 WL0__t4 \$62__t4 VSS__t250 nfet_03v3 L=0.28U W=0.24U AS=0.1022P
+ AD=0.1684P PS=0.96U PD=1.72U
* device instance $235 r0 *1 260.75,1.83 nfet
X$235 VSS__t47 \$62__t2 \$243__t4 VSS__t314 nfet_03v3 L=0.28U W=0.36U
+ AS=0.1022P AD=0.169P PS=0.96U PD=1.28U
* device instance $236 r0 *1 261.93,1.83 nfet
X$236 \$62__t3 \$243__t2 VSS__t79 VSS__t378 nfet_03v3 L=0.28U W=0.36U AS=0.169P
+ AD=0.1022P PS=1.28U PD=0.96U
* device instance $237 r0 *1 264.35,1.77 nfet
X$237 \$246__t3 WL0__t110 BL59__t0 VSS__t187 nfet_03v3 L=0.28U W=0.24U
+ AS=0.1684P AD=0.1022P PS=1.72U PD=0.96U
* device instance $238 r0 *1 267.25,1.77 nfet
X$238 BLB59__t0 WL0__t9 \$63__t4 VSS__t251 nfet_03v3 L=0.28U W=0.24U AS=0.1022P
+ AD=0.1684P PS=0.96U PD=1.72U
* device instance $239 r0 *1 265.21,1.83 nfet
X$239 VSS__t44 \$63__t2 \$246__t4 VSS__t315 nfet_03v3 L=0.28U W=0.36U
+ AS=0.1022P AD=0.169P PS=0.96U PD=1.28U
* device instance $240 r0 *1 266.39,1.83 nfet
X$240 \$63__t3 \$246__t2 VSS__t78 VSS__t379 nfet_03v3 L=0.28U W=0.36U AS=0.169P
+ AD=0.1022P PS=1.28U PD=0.96U
* device instance $241 r0 *1 268.81,1.77 nfet
X$241 \$249__t3 WL0__t112 BL60__t0 VSS__t188 nfet_03v3 L=0.28U W=0.24U
+ AS=0.1684P AD=0.1022P PS=1.72U PD=0.96U
* device instance $242 r0 *1 271.71,1.77 nfet
X$242 BLB60__t0 WL0__t15 \$64__t4 VSS__t252 nfet_03v3 L=0.28U W=0.24U
+ AS=0.1022P AD=0.1684P PS=0.96U PD=1.72U
* device instance $243 r0 *1 269.67,1.83 nfet
X$243 VSS__t50 \$64__t2 \$249__t4 VSS__t316 nfet_03v3 L=0.28U W=0.36U
+ AS=0.1022P AD=0.169P PS=0.96U PD=1.28U
* device instance $244 r0 *1 270.85,1.83 nfet
X$244 \$64__t3 \$249__t2 VSS__t75 VSS__t380 nfet_03v3 L=0.28U W=0.36U AS=0.169P
+ AD=0.1022P PS=1.28U PD=0.96U
* device instance $245 r0 *1 273.27,1.77 nfet
X$245 \$252__t3 WL0__t115 BL61__t0 VSS__t189 nfet_03v3 L=0.28U W=0.24U
+ AS=0.1684P AD=0.1022P PS=1.72U PD=0.96U
* device instance $246 r0 *1 276.17,1.77 nfet
X$246 BLB61__t0 WL0__t21 \$65__t4 VSS__t253 nfet_03v3 L=0.28U W=0.24U
+ AS=0.1022P AD=0.1684P PS=0.96U PD=1.72U
* device instance $247 r0 *1 274.13,1.83 nfet
X$247 VSS__t37 \$65__t2 \$252__t4 VSS__t317 nfet_03v3 L=0.28U W=0.36U
+ AS=0.1022P AD=0.169P PS=0.96U PD=1.28U
* device instance $248 r0 *1 275.31,1.83 nfet
X$248 \$65__t3 \$252__t2 VSS__t73 VSS__t381 nfet_03v3 L=0.28U W=0.36U AS=0.169P
+ AD=0.1022P PS=1.28U PD=0.96U
* device instance $249 r0 *1 277.73,1.77 nfet
X$249 \$255__t3 WL0__t127 BL62__t0 VSS__t190 nfet_03v3 L=0.28U W=0.24U
+ AS=0.1684P AD=0.1022P PS=1.72U PD=0.96U
* device instance $250 r0 *1 280.63,1.77 nfet
X$250 BLB62__t0 WL0__t10 \$66__t4 VSS__t254 nfet_03v3 L=0.28U W=0.24U
+ AS=0.1022P AD=0.1684P PS=0.96U PD=1.72U
* device instance $251 r0 *1 278.59,1.83 nfet
X$251 VSS__t41 \$66__t2 \$255__t4 VSS__t318 nfet_03v3 L=0.28U W=0.36U
+ AS=0.1022P AD=0.169P PS=0.96U PD=1.28U
* device instance $252 r0 *1 279.77,1.83 nfet
X$252 \$66__t3 \$255__t2 VSS__t71 VSS__t382 nfet_03v3 L=0.28U W=0.36U AS=0.169P
+ AD=0.1022P PS=1.28U PD=0.96U
* device instance $253 r0 *1 282.19,1.77 nfet
X$253 \$258__t3 WL0__t120 BL63__t0 VSS__t191 nfet_03v3 L=0.28U W=0.24U
+ AS=0.1684P AD=0.1022P PS=1.72U PD=0.96U
* device instance $254 r0 *1 285.09,1.77 nfet
X$254 BLB63__t0 WL0__t19 \$67__t4 VSS__t255 nfet_03v3 L=0.28U W=0.24U
+ AS=0.1022P AD=0.1684P PS=0.96U PD=1.72U
* device instance $255 r0 *1 283.05,1.83 nfet
X$255 VSS__t61 \$67__t2 \$258__t4 VSS__t319 nfet_03v3 L=0.28U W=0.36U
+ AS=0.1022P AD=0.169P PS=0.96U PD=1.28U
* device instance $256 r0 *1 284.23,1.83 nfet
X$256 \$67__t3 \$258__t2 VSS__t68 VSS__t383 nfet_03v3 L=0.28U W=0.36U AS=0.169P
+ AD=0.1022P PS=1.28U PD=0.96U
* device instance $257 r0 *1 2.07,3.72 pfet
X$257 VDD__t129 \$4__t1 \$69__t1 VDD__t0 pfet_03v3 L=0.28U W=0.22U AS=0.1664P
+ AD=0.155P PS=1.72U PD=1.28U
* device instance $258 r0 *1 3.25,3.72 pfet
X$258 \$4__t2 \$69__t2 VDD__t128 VDD__t1 pfet_03v3 L=0.28U W=0.22U AS=0.155P
+ AD=0.1664P PS=1.28U PD=1.72U
* device instance $259 r0 *1 6.53,3.72 pfet
X$259 VDD__t191 \$5__t1 \$72__t1 VDD__t126 pfet_03v3 L=0.28U W=0.22U AS=0.1664P
+ AD=0.155P PS=1.72U PD=1.28U
* device instance $260 r0 *1 7.71,3.72 pfet
X$260 \$5__t0 \$72__t0 VDD__t237 VDD__t46 pfet_03v3 L=0.28U W=0.22U AS=0.155P
+ AD=0.1664P PS=1.28U PD=1.72U
* device instance $261 r0 *1 10.99,3.72 pfet
X$261 VDD__t190 \$6__t1 \$75__t1 VDD__t125 pfet_03v3 L=0.28U W=0.22U AS=0.1664P
+ AD=0.155P PS=1.72U PD=1.28U
* device instance $262 r0 *1 12.17,3.72 pfet
X$262 \$6__t0 \$75__t0 VDD__t232 VDD__t41 pfet_03v3 L=0.28U W=0.22U AS=0.155P
+ AD=0.1664P PS=1.28U PD=1.72U
* device instance $263 r0 *1 15.45,3.72 pfet
X$263 VDD__t189 \$7__t1 \$78__t1 VDD__t124 pfet_03v3 L=0.28U W=0.22U AS=0.1664P
+ AD=0.155P PS=1.72U PD=1.28U
* device instance $264 r0 *1 16.63,3.72 pfet
X$264 \$7__t0 \$78__t0 VDD__t233 VDD__t42 pfet_03v3 L=0.28U W=0.22U AS=0.155P
+ AD=0.1664P PS=1.28U PD=1.72U
* device instance $265 r0 *1 19.91,3.72 pfet
X$265 VDD__t188 \$8__t1 \$81__t1 VDD__t123 pfet_03v3 L=0.28U W=0.22U AS=0.1664P
+ AD=0.155P PS=1.72U PD=1.28U
* device instance $266 r0 *1 21.09,3.72 pfet
X$266 \$8__t0 \$81__t0 VDD__t236 VDD__t45 pfet_03v3 L=0.28U W=0.22U AS=0.155P
+ AD=0.1664P PS=1.28U PD=1.72U
* device instance $267 r0 *1 24.37,3.72 pfet
X$267 VDD__t187 \$9__t1 \$84__t1 VDD__t122 pfet_03v3 L=0.28U W=0.22U AS=0.1664P
+ AD=0.155P PS=1.72U PD=1.28U
* device instance $268 r0 *1 25.55,3.72 pfet
X$268 \$9__t0 \$84__t0 VDD__t238 VDD__t47 pfet_03v3 L=0.28U W=0.22U AS=0.155P
+ AD=0.1664P PS=1.28U PD=1.72U
* device instance $269 r0 *1 28.83,3.72 pfet
X$269 VDD__t186 \$10__t1 \$87__t1 VDD__t121 pfet_03v3 L=0.28U W=0.22U
+ AS=0.1664P AD=0.155P PS=1.72U PD=1.28U
* device instance $270 r0 *1 30.01,3.72 pfet
X$270 \$10__t0 \$87__t0 VDD__t241 VDD__t50 pfet_03v3 L=0.28U W=0.22U AS=0.155P
+ AD=0.1664P PS=1.28U PD=1.72U
* device instance $271 r0 *1 33.29,3.72 pfet
X$271 VDD__t185 \$11__t1 \$90__t1 VDD__t120 pfet_03v3 L=0.28U W=0.22U
+ AS=0.1664P AD=0.155P PS=1.72U PD=1.28U
* device instance $272 r0 *1 34.47,3.72 pfet
X$272 \$11__t0 \$90__t0 VDD__t243 VDD__t52 pfet_03v3 L=0.28U W=0.22U AS=0.155P
+ AD=0.1664P PS=1.28U PD=1.72U
* device instance $273 r0 *1 37.75,3.72 pfet
X$273 VDD__t184 \$12__t1 \$93__t1 VDD__t119 pfet_03v3 L=0.28U W=0.22U
+ AS=0.1664P AD=0.155P PS=1.72U PD=1.28U
* device instance $274 r0 *1 38.93,3.72 pfet
X$274 \$12__t0 \$93__t0 VDD__t245 VDD__t54 pfet_03v3 L=0.28U W=0.22U AS=0.155P
+ AD=0.1664P PS=1.28U PD=1.72U
* device instance $275 r0 *1 42.21,3.72 pfet
X$275 VDD__t183 \$13__t1 \$96__t1 VDD__t118 pfet_03v3 L=0.28U W=0.22U
+ AS=0.1664P AD=0.155P PS=1.72U PD=1.28U
* device instance $276 r0 *1 43.39,3.72 pfet
X$276 \$13__t0 \$96__t0 VDD__t242 VDD__t51 pfet_03v3 L=0.28U W=0.22U AS=0.155P
+ AD=0.1664P PS=1.28U PD=1.72U
* device instance $277 r0 *1 46.67,3.72 pfet
X$277 VDD__t182 \$14__t1 \$99__t1 VDD__t117 pfet_03v3 L=0.28U W=0.22U
+ AS=0.1664P AD=0.155P PS=1.72U PD=1.28U
* device instance $278 r0 *1 47.85,3.72 pfet
X$278 \$14__t0 \$99__t0 VDD__t246 VDD__t55 pfet_03v3 L=0.28U W=0.22U AS=0.155P
+ AD=0.1664P PS=1.28U PD=1.72U
* device instance $279 r0 *1 51.13,3.72 pfet
X$279 VDD__t181 \$15__t1 \$102__t1 VDD__t116 pfet_03v3 L=0.28U W=0.22U
+ AS=0.1664P AD=0.155P PS=1.72U PD=1.28U
* device instance $280 r0 *1 52.31,3.72 pfet
X$280 \$15__t0 \$102__t0 VDD__t234 VDD__t43 pfet_03v3 L=0.28U W=0.22U AS=0.155P
+ AD=0.1664P PS=1.28U PD=1.72U
* device instance $281 r0 *1 55.59,3.72 pfet
X$281 VDD__t180 \$16__t1 \$105__t1 VDD__t115 pfet_03v3 L=0.28U W=0.22U
+ AS=0.1664P AD=0.155P PS=1.72U PD=1.28U
* device instance $282 r0 *1 56.77,3.72 pfet
X$282 \$16__t0 \$105__t0 VDD__t231 VDD__t40 pfet_03v3 L=0.28U W=0.22U AS=0.155P
+ AD=0.1664P PS=1.28U PD=1.72U
* device instance $283 r0 *1 60.05,3.72 pfet
X$283 VDD__t179 \$17__t1 \$108__t1 VDD__t114 pfet_03v3 L=0.28U W=0.22U
+ AS=0.1664P AD=0.155P PS=1.72U PD=1.28U
* device instance $284 r0 *1 61.23,3.72 pfet
X$284 \$17__t0 \$108__t0 VDD__t253 VDD__t62 pfet_03v3 L=0.28U W=0.22U AS=0.155P
+ AD=0.1664P PS=1.28U PD=1.72U
* device instance $285 r0 *1 64.51,3.72 pfet
X$285 VDD__t178 \$18__t1 \$111__t1 VDD__t113 pfet_03v3 L=0.28U W=0.22U
+ AS=0.1664P AD=0.155P PS=1.72U PD=1.28U
* device instance $286 r0 *1 65.69,3.72 pfet
X$286 \$18__t0 \$111__t0 VDD__t247 VDD__t56 pfet_03v3 L=0.28U W=0.22U AS=0.155P
+ AD=0.1664P PS=1.28U PD=1.72U
* device instance $287 r0 *1 68.97,3.72 pfet
X$287 VDD__t177 \$19__t1 \$114__t1 VDD__t112 pfet_03v3 L=0.28U W=0.22U
+ AS=0.1664P AD=0.155P PS=1.72U PD=1.28U
* device instance $288 r0 *1 70.15,3.72 pfet
X$288 \$19__t0 \$114__t0 VDD__t255 VDD__t64 pfet_03v3 L=0.28U W=0.22U AS=0.155P
+ AD=0.1664P PS=1.28U PD=1.72U
* device instance $289 r0 *1 73.43,3.72 pfet
X$289 VDD__t192 \$20__t1 \$117__t1 VDD__t127 pfet_03v3 L=0.28U W=0.22U
+ AS=0.1664P AD=0.155P PS=1.72U PD=1.28U
* device instance $290 r0 *1 74.61,3.72 pfet
X$290 \$20__t0 \$117__t0 VDD__t225 VDD__t34 pfet_03v3 L=0.28U W=0.22U AS=0.155P
+ AD=0.1664P PS=1.28U PD=1.72U
* device instance $291 r0 *1 77.89,3.72 pfet
X$291 VDD__t142 \$21__t1 \$120__t1 VDD__t77 pfet_03v3 L=0.28U W=0.22U
+ AS=0.1664P AD=0.155P PS=1.72U PD=1.28U
* device instance $292 r0 *1 79.07,3.72 pfet
X$292 \$21__t0 \$120__t0 VDD__t224 VDD__t33 pfet_03v3 L=0.28U W=0.22U AS=0.155P
+ AD=0.1664P PS=1.28U PD=1.72U
* device instance $293 r0 *1 82.35,3.72 pfet
X$293 VDD__t131 \$22__t1 \$123__t1 VDD__t66 pfet_03v3 L=0.28U W=0.22U
+ AS=0.1664P AD=0.155P PS=1.72U PD=1.28U
* device instance $294 r0 *1 83.53,3.72 pfet
X$294 \$22__t0 \$123__t0 VDD__t223 VDD__t32 pfet_03v3 L=0.28U W=0.22U AS=0.155P
+ AD=0.1664P PS=1.28U PD=1.72U
* device instance $295 r0 *1 86.81,3.72 pfet
X$295 VDD__t132 \$23__t1 \$126__t1 VDD__t67 pfet_03v3 L=0.28U W=0.22U
+ AS=0.1664P AD=0.155P PS=1.72U PD=1.28U
* device instance $296 r0 *1 87.99,3.72 pfet
X$296 \$23__t0 \$126__t0 VDD__t222 VDD__t31 pfet_03v3 L=0.28U W=0.22U AS=0.155P
+ AD=0.1664P PS=1.28U PD=1.72U
* device instance $297 r0 *1 91.27,3.72 pfet
X$297 VDD__t136 \$24__t1 \$129__t1 VDD__t71 pfet_03v3 L=0.28U W=0.22U
+ AS=0.1664P AD=0.155P PS=1.72U PD=1.28U
* device instance $298 r0 *1 92.45,3.72 pfet
X$298 \$24__t0 \$129__t0 VDD__t221 VDD__t30 pfet_03v3 L=0.28U W=0.22U AS=0.155P
+ AD=0.1664P PS=1.28U PD=1.72U
* device instance $299 r0 *1 95.73,3.72 pfet
X$299 VDD__t147 \$25__t1 \$132__t1 VDD__t82 pfet_03v3 L=0.28U W=0.22U
+ AS=0.1664P AD=0.155P PS=1.72U PD=1.28U
* device instance $300 r0 *1 96.91,3.72 pfet
X$300 \$25__t0 \$132__t0 VDD__t220 VDD__t29 pfet_03v3 L=0.28U W=0.22U AS=0.155P
+ AD=0.1664P PS=1.28U PD=1.72U
* device instance $301 r0 *1 100.19,3.72 pfet
X$301 VDD__t139 \$26__t1 \$135__t1 VDD__t74 pfet_03v3 L=0.28U W=0.22U
+ AS=0.1664P AD=0.155P PS=1.72U PD=1.28U
* device instance $302 r0 *1 101.37,3.72 pfet
X$302 \$26__t0 \$135__t0 VDD__t229 VDD__t38 pfet_03v3 L=0.28U W=0.22U AS=0.155P
+ AD=0.1664P PS=1.28U PD=1.72U
* device instance $303 r0 *1 104.65,3.72 pfet
X$303 VDD__t141 \$27__t1 \$138__t1 VDD__t76 pfet_03v3 L=0.28U W=0.22U
+ AS=0.1664P AD=0.155P PS=1.72U PD=1.28U
* device instance $304 r0 *1 105.83,3.72 pfet
X$304 \$27__t0 \$138__t0 VDD__t218 VDD__t27 pfet_03v3 L=0.28U W=0.22U AS=0.155P
+ AD=0.1664P PS=1.28U PD=1.72U
* device instance $305 r0 *1 109.11,3.72 pfet
X$305 VDD__t143 \$28__t1 \$141__t1 VDD__t78 pfet_03v3 L=0.28U W=0.22U
+ AS=0.1664P AD=0.155P PS=1.72U PD=1.28U
* device instance $306 r0 *1 110.29,3.72 pfet
X$306 \$28__t0 \$141__t0 VDD__t217 VDD__t26 pfet_03v3 L=0.28U W=0.22U AS=0.155P
+ AD=0.1664P PS=1.28U PD=1.72U
* device instance $307 r0 *1 113.57,3.72 pfet
X$307 VDD__t146 \$29__t1 \$144__t1 VDD__t81 pfet_03v3 L=0.28U W=0.22U
+ AS=0.1664P AD=0.155P PS=1.72U PD=1.28U
* device instance $308 r0 *1 114.75,3.72 pfet
X$308 \$29__t0 \$144__t0 VDD__t216 VDD__t25 pfet_03v3 L=0.28U W=0.22U AS=0.155P
+ AD=0.1664P PS=1.28U PD=1.72U
* device instance $309 r0 *1 118.03,3.72 pfet
X$309 VDD__t144 \$30__t1 \$147__t1 VDD__t79 pfet_03v3 L=0.28U W=0.22U
+ AS=0.1664P AD=0.155P PS=1.72U PD=1.28U
* device instance $310 r0 *1 119.21,3.72 pfet
X$310 \$30__t0 \$147__t0 VDD__t215 VDD__t24 pfet_03v3 L=0.28U W=0.22U AS=0.155P
+ AD=0.1664P PS=1.28U PD=1.72U
* device instance $311 r0 *1 122.49,3.72 pfet
X$311 VDD__t140 \$31__t1 \$150__t1 VDD__t75 pfet_03v3 L=0.28U W=0.22U
+ AS=0.1664P AD=0.155P PS=1.72U PD=1.28U
* device instance $312 r0 *1 123.67,3.72 pfet
X$312 \$31__t0 \$150__t0 VDD__t214 VDD__t23 pfet_03v3 L=0.28U W=0.22U AS=0.155P
+ AD=0.1664P PS=1.28U PD=1.72U
* device instance $313 r0 *1 126.95,3.72 pfet
X$313 VDD__t137 \$32__t1 \$153__t1 VDD__t72 pfet_03v3 L=0.28U W=0.22U
+ AS=0.1664P AD=0.155P PS=1.72U PD=1.28U
* device instance $314 r0 *1 128.13,3.72 pfet
X$314 \$32__t0 \$153__t0 VDD__t213 VDD__t22 pfet_03v3 L=0.28U W=0.22U AS=0.155P
+ AD=0.1664P PS=1.28U PD=1.72U
* device instance $315 r0 *1 131.41,3.72 pfet
X$315 VDD__t134 \$33__t1 \$156__t1 VDD__t69 pfet_03v3 L=0.28U W=0.22U
+ AS=0.1664P AD=0.155P PS=1.72U PD=1.28U
* device instance $316 r0 *1 132.59,3.72 pfet
X$316 \$33__t0 \$156__t0 VDD__t212 VDD__t21 pfet_03v3 L=0.28U W=0.22U AS=0.155P
+ AD=0.1664P PS=1.28U PD=1.72U
* device instance $317 r0 *1 135.87,3.72 pfet
X$317 VDD__t130 \$34__t1 \$159__t1 VDD__t65 pfet_03v3 L=0.28U W=0.22U
+ AS=0.1664P AD=0.155P PS=1.72U PD=1.28U
* device instance $318 r0 *1 137.05,3.72 pfet
X$318 \$34__t0 \$159__t0 VDD__t211 VDD__t20 pfet_03v3 L=0.28U W=0.22U AS=0.155P
+ AD=0.1664P PS=1.28U PD=1.72U
* device instance $319 r0 *1 140.33,3.72 pfet
X$319 VDD__t161 \$35__t1 \$162__t1 VDD__t96 pfet_03v3 L=0.28U W=0.22U
+ AS=0.1664P AD=0.155P PS=1.72U PD=1.28U
* device instance $320 r0 *1 141.51,3.72 pfet
X$320 \$35__t0 \$162__t0 VDD__t254 VDD__t63 pfet_03v3 L=0.28U W=0.22U AS=0.155P
+ AD=0.1664P PS=1.28U PD=1.72U
* device instance $321 r0 *1 144.79,3.72 pfet
X$321 VDD__t156 \$36__t1 \$165__t1 VDD__t91 pfet_03v3 L=0.28U W=0.22U
+ AS=0.1664P AD=0.155P PS=1.72U PD=1.28U
* device instance $322 r0 *1 145.97,3.72 pfet
X$322 \$36__t0 \$165__t0 VDD__t204 VDD__t13 pfet_03v3 L=0.28U W=0.22U AS=0.155P
+ AD=0.1664P PS=1.28U PD=1.72U
* device instance $323 r0 *1 149.25,3.72 pfet
X$323 VDD__t157 \$37__t1 \$168__t1 VDD__t92 pfet_03v3 L=0.28U W=0.22U
+ AS=0.1664P AD=0.155P PS=1.72U PD=1.28U
* device instance $324 r0 *1 150.43,3.72 pfet
X$324 \$37__t0 \$168__t0 VDD__t203 VDD__t12 pfet_03v3 L=0.28U W=0.22U AS=0.155P
+ AD=0.1664P PS=1.28U PD=1.72U
* device instance $325 r0 *1 153.71,3.72 pfet
X$325 VDD__t159 \$38__t1 \$171__t1 VDD__t94 pfet_03v3 L=0.28U W=0.22U
+ AS=0.1664P AD=0.155P PS=1.72U PD=1.28U
* device instance $326 r0 *1 154.89,3.72 pfet
X$326 \$38__t0 \$171__t0 VDD__t202 VDD__t11 pfet_03v3 L=0.28U W=0.22U AS=0.155P
+ AD=0.1664P PS=1.28U PD=1.72U
* device instance $327 r0 *1 158.17,3.72 pfet
X$327 VDD__t160 \$39__t1 \$174__t1 VDD__t95 pfet_03v3 L=0.28U W=0.22U
+ AS=0.1664P AD=0.155P PS=1.72U PD=1.28U
* device instance $328 r0 *1 159.35,3.72 pfet
X$328 \$39__t0 \$174__t0 VDD__t210 VDD__t19 pfet_03v3 L=0.28U W=0.22U AS=0.155P
+ AD=0.1664P PS=1.28U PD=1.72U
* device instance $329 r0 *1 162.63,3.72 pfet
X$329 VDD__t176 \$40__t1 \$177__t1 VDD__t111 pfet_03v3 L=0.28U W=0.22U
+ AS=0.1664P AD=0.155P PS=1.72U PD=1.28U
* device instance $330 r0 *1 163.81,3.72 pfet
X$330 \$40__t0 \$177__t0 VDD__t200 VDD__t9 pfet_03v3 L=0.28U W=0.22U AS=0.155P
+ AD=0.1664P PS=1.28U PD=1.72U
* device instance $331 r0 *1 167.09,3.72 pfet
X$331 VDD__t162 \$41__t1 \$180__t1 VDD__t97 pfet_03v3 L=0.28U W=0.22U
+ AS=0.1664P AD=0.155P PS=1.72U PD=1.28U
* device instance $332 r0 *1 168.27,3.72 pfet
X$332 \$41__t0 \$180__t0 VDD__t199 VDD__t8 pfet_03v3 L=0.28U W=0.22U AS=0.155P
+ AD=0.1664P PS=1.28U PD=1.72U
* device instance $333 r0 *1 171.55,3.72 pfet
X$333 VDD__t164 \$42__t1 \$183__t1 VDD__t99 pfet_03v3 L=0.28U W=0.22U
+ AS=0.1664P AD=0.155P PS=1.72U PD=1.28U
* device instance $334 r0 *1 172.73,3.72 pfet
X$334 \$42__t0 \$183__t0 VDD__t198 VDD__t7 pfet_03v3 L=0.28U W=0.22U AS=0.155P
+ AD=0.1664P PS=1.28U PD=1.72U
* device instance $335 r0 *1 176.01,3.72 pfet
X$335 VDD__t165 \$43__t1 \$186__t1 VDD__t100 pfet_03v3 L=0.28U W=0.22U
+ AS=0.1664P AD=0.155P PS=1.72U PD=1.28U
* device instance $336 r0 *1 177.19,3.72 pfet
X$336 \$43__t0 \$186__t0 VDD__t197 VDD__t6 pfet_03v3 L=0.28U W=0.22U AS=0.155P
+ AD=0.1664P PS=1.28U PD=1.72U
* device instance $337 r0 *1 180.47,3.72 pfet
X$337 VDD__t166 \$44__t1 \$189__t1 VDD__t101 pfet_03v3 L=0.28U W=0.22U
+ AS=0.1664P AD=0.155P PS=1.72U PD=1.28U
* device instance $338 r0 *1 181.65,3.72 pfet
X$338 \$44__t0 \$189__t0 VDD__t196 VDD__t5 pfet_03v3 L=0.28U W=0.22U AS=0.155P
+ AD=0.1664P PS=1.28U PD=1.72U
* device instance $339 r0 *1 184.93,3.72 pfet
X$339 VDD__t167 \$45__t1 \$192__t1 VDD__t102 pfet_03v3 L=0.28U W=0.22U
+ AS=0.1664P AD=0.155P PS=1.72U PD=1.28U
* device instance $340 r0 *1 186.11,3.72 pfet
X$340 \$45__t0 \$192__t0 VDD__t195 VDD__t4 pfet_03v3 L=0.28U W=0.22U AS=0.155P
+ AD=0.1664P PS=1.28U PD=1.72U
* device instance $341 r0 *1 189.39,3.72 pfet
X$341 VDD__t169 \$46__t1 \$195__t1 VDD__t104 pfet_03v3 L=0.28U W=0.22U
+ AS=0.1664P AD=0.155P PS=1.72U PD=1.28U
* device instance $342 r0 *1 190.57,3.72 pfet
X$342 \$46__t0 \$195__t0 VDD__t194 VDD__t3 pfet_03v3 L=0.28U W=0.22U AS=0.155P
+ AD=0.1664P PS=1.28U PD=1.72U
* device instance $343 r0 *1 193.85,3.72 pfet
X$343 VDD__t170 \$47__t1 \$198__t1 VDD__t105 pfet_03v3 L=0.28U W=0.22U
+ AS=0.1664P AD=0.155P PS=1.72U PD=1.28U
* device instance $344 r0 *1 195.03,3.72 pfet
X$344 \$47__t0 \$198__t0 VDD__t193 VDD__t2 pfet_03v3 L=0.28U W=0.22U AS=0.155P
+ AD=0.1664P PS=1.28U PD=1.72U
* device instance $345 r0 *1 198.31,3.72 pfet
X$345 VDD__t171 \$48__t1 \$201__t1 VDD__t106 pfet_03v3 L=0.28U W=0.22U
+ AS=0.1664P AD=0.155P PS=1.72U PD=1.28U
* device instance $346 r0 *1 199.49,3.72 pfet
X$346 \$48__t0 \$201__t0 VDD__t219 VDD__t28 pfet_03v3 L=0.28U W=0.22U AS=0.155P
+ AD=0.1664P PS=1.28U PD=1.72U
* device instance $347 r0 *1 202.77,3.72 pfet
X$347 VDD__t172 \$49__t1 \$204__t1 VDD__t107 pfet_03v3 L=0.28U W=0.22U
+ AS=0.1664P AD=0.155P PS=1.72U PD=1.28U
* device instance $348 r0 *1 203.95,3.72 pfet
X$348 \$49__t0 \$204__t0 VDD__t228 VDD__t37 pfet_03v3 L=0.28U W=0.22U AS=0.155P
+ AD=0.1664P PS=1.28U PD=1.72U
* device instance $349 r0 *1 207.23,3.72 pfet
X$349 VDD__t174 \$50__t1 \$207__t1 VDD__t109 pfet_03v3 L=0.28U W=0.22U
+ AS=0.1664P AD=0.155P PS=1.72U PD=1.28U
* device instance $350 r0 *1 208.41,3.72 pfet
X$350 \$50__t0 \$207__t0 VDD__t227 VDD__t36 pfet_03v3 L=0.28U W=0.22U AS=0.155P
+ AD=0.1664P PS=1.28U PD=1.72U
* device instance $351 r0 *1 211.69,3.72 pfet
X$351 VDD__t175 \$51__t1 \$210__t1 VDD__t110 pfet_03v3 L=0.28U W=0.22U
+ AS=0.1664P AD=0.155P PS=1.72U PD=1.28U
* device instance $352 r0 *1 212.87,3.72 pfet
X$352 \$51__t0 \$210__t0 VDD__t226 VDD__t35 pfet_03v3 L=0.28U W=0.22U AS=0.155P
+ AD=0.1664P PS=1.28U PD=1.72U
* device instance $353 r0 *1 216.15,3.72 pfet
X$353 VDD__t133 \$52__t1 \$213__t1 VDD__t68 pfet_03v3 L=0.28U W=0.22U
+ AS=0.1664P AD=0.155P PS=1.72U PD=1.28U
* device instance $354 r0 *1 217.33,3.72 pfet
X$354 \$52__t0 \$213__t0 VDD__t250 VDD__t59 pfet_03v3 L=0.28U W=0.22U AS=0.155P
+ AD=0.1664P PS=1.28U PD=1.72U
* device instance $355 r0 *1 220.61,3.72 pfet
X$355 VDD__t145 \$53__t1 \$216__t1 VDD__t80 pfet_03v3 L=0.28U W=0.22U
+ AS=0.1664P AD=0.155P PS=1.72U PD=1.28U
* device instance $356 r0 *1 221.79,3.72 pfet
X$356 \$53__t0 \$216__t0 VDD__t249 VDD__t58 pfet_03v3 L=0.28U W=0.22U AS=0.155P
+ AD=0.1664P PS=1.28U PD=1.72U
* device instance $357 r0 *1 225.07,3.72 pfet
X$357 VDD__t138 \$54__t1 \$219__t1 VDD__t73 pfet_03v3 L=0.28U W=0.22U
+ AS=0.1664P AD=0.155P PS=1.72U PD=1.28U
* device instance $358 r0 *1 226.25,3.72 pfet
X$358 \$54__t0 \$219__t0 VDD__t240 VDD__t49 pfet_03v3 L=0.28U W=0.22U AS=0.155P
+ AD=0.1664P PS=1.28U PD=1.72U
* device instance $359 r0 *1 229.53,3.72 pfet
X$359 VDD__t135 \$55__t1 \$222__t1 VDD__t70 pfet_03v3 L=0.28U W=0.22U
+ AS=0.1664P AD=0.155P PS=1.72U PD=1.28U
* device instance $360 r0 *1 230.71,3.72 pfet
X$360 \$55__t0 \$222__t0 VDD__t244 VDD__t53 pfet_03v3 L=0.28U W=0.22U AS=0.155P
+ AD=0.1664P PS=1.28U PD=1.72U
* device instance $361 r0 *1 233.99,3.72 pfet
X$361 VDD__t173 \$56__t1 \$225__t1 VDD__t108 pfet_03v3 L=0.28U W=0.22U
+ AS=0.1664P AD=0.155P PS=1.72U PD=1.28U
* device instance $362 r0 *1 235.17,3.72 pfet
X$362 \$56__t0 \$225__t0 VDD__t239 VDD__t48 pfet_03v3 L=0.28U W=0.22U AS=0.155P
+ AD=0.1664P PS=1.28U PD=1.72U
* device instance $363 r0 *1 238.45,3.72 pfet
X$363 VDD__t168 \$57__t1 \$228__t1 VDD__t103 pfet_03v3 L=0.28U W=0.22U
+ AS=0.1664P AD=0.155P PS=1.72U PD=1.28U
* device instance $364 r0 *1 239.63,3.72 pfet
X$364 \$57__t0 \$228__t0 VDD__t235 VDD__t44 pfet_03v3 L=0.28U W=0.22U AS=0.155P
+ AD=0.1664P PS=1.28U PD=1.72U
* device instance $365 r0 *1 242.91,3.72 pfet
X$365 VDD__t163 \$58__t1 \$231__t1 VDD__t98 pfet_03v3 L=0.28U W=0.22U
+ AS=0.1664P AD=0.155P PS=1.72U PD=1.28U
* device instance $366 r0 *1 244.09,3.72 pfet
X$366 \$58__t0 \$231__t0 VDD__t230 VDD__t39 pfet_03v3 L=0.28U W=0.22U AS=0.155P
+ AD=0.1664P PS=1.28U PD=1.72U
* device instance $367 r0 *1 247.37,3.72 pfet
X$367 VDD__t158 \$59__t1 \$234__t1 VDD__t93 pfet_03v3 L=0.28U W=0.22U
+ AS=0.1664P AD=0.155P PS=1.72U PD=1.28U
* device instance $368 r0 *1 248.55,3.72 pfet
X$368 \$59__t0 \$234__t0 VDD__t251 VDD__t60 pfet_03v3 L=0.28U W=0.22U AS=0.155P
+ AD=0.1664P PS=1.28U PD=1.72U
* device instance $369 r0 *1 251.83,3.72 pfet
X$369 VDD__t154 \$60__t1 \$237__t1 VDD__t89 pfet_03v3 L=0.28U W=0.22U
+ AS=0.1664P AD=0.155P PS=1.72U PD=1.28U
* device instance $370 r0 *1 253.01,3.72 pfet
X$370 \$60__t0 \$237__t0 VDD__t248 VDD__t57 pfet_03v3 L=0.28U W=0.22U AS=0.155P
+ AD=0.1664P PS=1.28U PD=1.72U
* device instance $371 r0 *1 256.29,3.72 pfet
X$371 VDD__t151 \$61__t1 \$240__t1 VDD__t86 pfet_03v3 L=0.28U W=0.22U
+ AS=0.1664P AD=0.155P PS=1.72U PD=1.28U
* device instance $372 r0 *1 257.47,3.72 pfet
X$372 \$61__t0 \$240__t0 VDD__t252 VDD__t61 pfet_03v3 L=0.28U W=0.22U AS=0.155P
+ AD=0.1664P PS=1.28U PD=1.72U
* device instance $373 r0 *1 260.75,3.72 pfet
X$373 VDD__t148 \$62__t1 \$243__t1 VDD__t83 pfet_03v3 L=0.28U W=0.22U
+ AS=0.1664P AD=0.155P PS=1.72U PD=1.28U
* device instance $374 r0 *1 261.93,3.72 pfet
X$374 \$62__t0 \$243__t0 VDD__t201 VDD__t10 pfet_03v3 L=0.28U W=0.22U AS=0.155P
+ AD=0.1664P PS=1.28U PD=1.72U
* device instance $375 r0 *1 265.21,3.72 pfet
X$375 VDD__t149 \$63__t1 \$246__t1 VDD__t84 pfet_03v3 L=0.28U W=0.22U
+ AS=0.1664P AD=0.155P PS=1.72U PD=1.28U
* device instance $376 r0 *1 266.39,3.72 pfet
X$376 \$63__t0 \$246__t0 VDD__t209 VDD__t18 pfet_03v3 L=0.28U W=0.22U AS=0.155P
+ AD=0.1664P PS=1.28U PD=1.72U
* device instance $377 r0 *1 269.67,3.72 pfet
X$377 VDD__t150 \$64__t1 \$249__t1 VDD__t85 pfet_03v3 L=0.28U W=0.22U
+ AS=0.1664P AD=0.155P PS=1.72U PD=1.28U
* device instance $378 r0 *1 270.85,3.72 pfet
X$378 \$64__t0 \$249__t0 VDD__t208 VDD__t17 pfet_03v3 L=0.28U W=0.22U AS=0.155P
+ AD=0.1664P PS=1.28U PD=1.72U
* device instance $379 r0 *1 274.13,3.72 pfet
X$379 VDD__t152 \$65__t1 \$252__t1 VDD__t87 pfet_03v3 L=0.28U W=0.22U
+ AS=0.1664P AD=0.155P PS=1.72U PD=1.28U
* device instance $380 r0 *1 275.31,3.72 pfet
X$380 \$65__t0 \$252__t0 VDD__t207 VDD__t16 pfet_03v3 L=0.28U W=0.22U AS=0.155P
+ AD=0.1664P PS=1.28U PD=1.72U
* device instance $381 r0 *1 278.59,3.72 pfet
X$381 VDD__t153 \$66__t1 \$255__t1 VDD__t88 pfet_03v3 L=0.28U W=0.22U
+ AS=0.1664P AD=0.155P PS=1.72U PD=1.28U
* device instance $382 r0 *1 279.77,3.72 pfet
X$382 \$66__t0 \$255__t0 VDD__t206 VDD__t15 pfet_03v3 L=0.28U W=0.22U AS=0.155P
+ AD=0.1664P PS=1.28U PD=1.72U
* device instance $383 r0 *1 283.05,3.72 pfet
X$383 VDD__t155 \$67__t1 \$258__t1 VDD__t90 pfet_03v3 L=0.28U W=0.22U
+ AS=0.1664P AD=0.155P PS=1.72U PD=1.28U
* device instance $384 r0 *1 284.23,3.72 pfet
X$384 \$67__t0 \$258__t0 VDD__t205 VDD__t14 pfet_03v3 L=0.28U W=0.22U AS=0.155P
+ AD=0.1664P PS=1.28U PD=1.72U
* device instance _10_t0 r0 *1 0,0
R_10_t0 \$10__t0 \$10 14.0706287935
* device instance _10_t1 r0 *1 0,0
R_10_t1 \$10__t1 \$10 17.162141452
* device instance _10_t2 r0 *1 0,0
R_10_t2 \$10__t2 \$10 13.6875065396
* device instance _10_t3 r0 *1 0,0
R_10_t3 \$10__t3 \$10 9.52844849363
* device instance _10_t4 r0 *1 0,0
R_10_t4 \$10__t4 \$10 16.7641747213
* device instance _10 r0 *1 0,0
C_10 \$10 vsubs 7.92193e-16
* device instance _102_t0 r0 *1 0,0
R_102_t0 \$102__t0 \$102 17.162141452
* device instance _102_t1 r0 *1 0,0
R_102_t1 \$102__t1 \$102 14.0706287935
* device instance _102_t2 r0 *1 0,0
R_102_t2 \$102__t2 \$102 13.6875065396
* device instance _102_t3 r0 *1 0,0
R_102_t3 \$102__t3 \$102 16.7641747213
* device instance _102_t4 r0 *1 0,0
R_102_t4 \$102__t4 \$102 9.52844849363
* device instance _102 r0 *1 0,0
C_102 \$102 vsubs 7.83841e-16
* device instance _105_t0 r0 *1 0,0
R_105_t0 \$105__t0 \$105 17.162141452
* device instance _105_t1 r0 *1 0,0
R_105_t1 \$105__t1 \$105 14.0706287935
* device instance _105_t2 r0 *1 0,0
R_105_t2 \$105__t2 \$105 13.6875065396
* device instance _105_t3 r0 *1 0,0
R_105_t3 \$105__t3 \$105 16.7641747213
* device instance _105_t4 r0 *1 0,0
R_105_t4 \$105__t4 \$105 9.52844849363
* device instance _105 r0 *1 0,0
C_105 \$105 vsubs 7.83841e-16
* device instance _108_t0 r0 *1 0,0
R_108_t0 \$108__t0 \$108 17.162141452
* device instance _108_t1 r0 *1 0,0
R_108_t1 \$108__t1 \$108 14.0706287935
* device instance _108_t2 r0 *1 0,0
R_108_t2 \$108__t2 \$108 13.6875065396
* device instance _108_t3 r0 *1 0,0
R_108_t3 \$108__t3 \$108 16.7641747213
* device instance _108_t4 r0 *1 0,0
R_108_t4 \$108__t4 \$108 9.52844849363
* device instance _108 r0 *1 0,0
C_108 \$108 vsubs 7.83841e-16
* device instance _11_t0 r0 *1 0,0
R_11_t0 \$11__t0 \$11 14.0706287935
* device instance _11_t1 r0 *1 0,0
R_11_t1 \$11__t1 \$11 17.162141452
* device instance _11_t2 r0 *1 0,0
R_11_t2 \$11__t2 \$11 13.6875065396
* device instance _11_t3 r0 *1 0,0
R_11_t3 \$11__t3 \$11 9.52844849363
* device instance _11_t4 r0 *1 0,0
R_11_t4 \$11__t4 \$11 16.7641747213
* device instance _11 r0 *1 0,0
C_11 \$11 vsubs 7.92193e-16
* device instance _111_t0 r0 *1 0,0
R_111_t0 \$111__t0 \$111 17.162141452
* device instance _111_t1 r0 *1 0,0
R_111_t1 \$111__t1 \$111 14.0706287935
* device instance _111_t2 r0 *1 0,0
R_111_t2 \$111__t2 \$111 13.6875065396
* device instance _111_t3 r0 *1 0,0
R_111_t3 \$111__t3 \$111 16.7641747213
* device instance _111_t4 r0 *1 0,0
R_111_t4 \$111__t4 \$111 9.52844849363
* device instance _111 r0 *1 0,0
C_111 \$111 vsubs 7.83841e-16
* device instance _114_t0 r0 *1 0,0
R_114_t0 \$114__t0 \$114 17.162141452
* device instance _114_t1 r0 *1 0,0
R_114_t1 \$114__t1 \$114 14.0706287935
* device instance _114_t2 r0 *1 0,0
R_114_t2 \$114__t2 \$114 13.6875065396
* device instance _114_t3 r0 *1 0,0
R_114_t3 \$114__t3 \$114 16.7641747213
* device instance _114_t4 r0 *1 0,0
R_114_t4 \$114__t4 \$114 9.52844849363
* device instance _114 r0 *1 0,0
C_114 \$114 vsubs 7.83841e-16
* device instance _117_t0 r0 *1 0,0
R_117_t0 \$117__t0 \$117 17.162141452
* device instance _117_t1 r0 *1 0,0
R_117_t1 \$117__t1 \$117 14.0706287935
* device instance _117_t2 r0 *1 0,0
R_117_t2 \$117__t2 \$117 13.6875065396
* device instance _117_t3 r0 *1 0,0
R_117_t3 \$117__t3 \$117 16.7641747213
* device instance _117_t4 r0 *1 0,0
R_117_t4 \$117__t4 \$117 9.52844849363
* device instance _117 r0 *1 0,0
C_117 \$117 vsubs 7.83841e-16
* device instance _12_t0 r0 *1 0,0
R_12_t0 \$12__t0 \$12 14.0706287935
* device instance _12_t1 r0 *1 0,0
R_12_t1 \$12__t1 \$12 17.162141452
* device instance _12_t2 r0 *1 0,0
R_12_t2 \$12__t2 \$12 13.6875065396
* device instance _12_t3 r0 *1 0,0
R_12_t3 \$12__t3 \$12 9.52844849363
* device instance _12_t4 r0 *1 0,0
R_12_t4 \$12__t4 \$12 16.7641747213
* device instance _12 r0 *1 0,0
C_12 \$12 vsubs 7.92193e-16
* device instance _120_t0 r0 *1 0,0
R_120_t0 \$120__t0 \$120 17.162141452
* device instance _120_t1 r0 *1 0,0
R_120_t1 \$120__t1 \$120 14.0706287935
* device instance _120_t2 r0 *1 0,0
R_120_t2 \$120__t2 \$120 13.6875065396
* device instance _120_t3 r0 *1 0,0
R_120_t3 \$120__t3 \$120 16.7641747213
* device instance _120_t4 r0 *1 0,0
R_120_t4 \$120__t4 \$120 9.52844849363
* device instance _120 r0 *1 0,0
C_120 \$120 vsubs 7.83841e-16
* device instance _123_t0 r0 *1 0,0
R_123_t0 \$123__t0 \$123 17.162141452
* device instance _123_t1 r0 *1 0,0
R_123_t1 \$123__t1 \$123 14.0706287935
* device instance _123_t2 r0 *1 0,0
R_123_t2 \$123__t2 \$123 13.6875065396
* device instance _123_t3 r0 *1 0,0
R_123_t3 \$123__t3 \$123 16.7641747213
* device instance _123_t4 r0 *1 0,0
R_123_t4 \$123__t4 \$123 9.52844849363
* device instance _123 r0 *1 0,0
C_123 \$123 vsubs 7.83841e-16
* device instance _126_t0 r0 *1 0,0
R_126_t0 \$126__t0 \$126 17.162141452
* device instance _126_t1 r0 *1 0,0
R_126_t1 \$126__t1 \$126 14.0706287935
* device instance _126_t2 r0 *1 0,0
R_126_t2 \$126__t2 \$126 13.6875065396
* device instance _126_t3 r0 *1 0,0
R_126_t3 \$126__t3 \$126 16.7641747213
* device instance _126_t4 r0 *1 0,0
R_126_t4 \$126__t4 \$126 9.52844849363
* device instance _126 r0 *1 0,0
C_126 \$126 vsubs 7.83841e-16
* device instance _129_t0 r0 *1 0,0
R_129_t0 \$129__t0 \$129 17.162141452
* device instance _129_t1 r0 *1 0,0
R_129_t1 \$129__t1 \$129 14.0706287935
* device instance _129_t2 r0 *1 0,0
R_129_t2 \$129__t2 \$129 13.6875065396
* device instance _129_t3 r0 *1 0,0
R_129_t3 \$129__t3 \$129 16.7641747213
* device instance _129_t4 r0 *1 0,0
R_129_t4 \$129__t4 \$129 9.52844849363
* device instance _129 r0 *1 0,0
C_129 \$129 vsubs 7.83841e-16
* device instance _13_t0 r0 *1 0,0
R_13_t0 \$13__t0 \$13 14.0706287935
* device instance _13_t1 r0 *1 0,0
R_13_t1 \$13__t1 \$13 17.162141452
* device instance _13_t2 r0 *1 0,0
R_13_t2 \$13__t2 \$13 13.6875065396
* device instance _13_t3 r0 *1 0,0
R_13_t3 \$13__t3 \$13 9.52844849363
* device instance _13_t4 r0 *1 0,0
R_13_t4 \$13__t4 \$13 16.7641747213
* device instance _13 r0 *1 0,0
C_13 \$13 vsubs 7.92193e-16
* device instance _132_t0 r0 *1 0,0
R_132_t0 \$132__t0 \$132 17.162141452
* device instance _132_t1 r0 *1 0,0
R_132_t1 \$132__t1 \$132 14.0706287935
* device instance _132_t2 r0 *1 0,0
R_132_t2 \$132__t2 \$132 13.6875065396
* device instance _132_t3 r0 *1 0,0
R_132_t3 \$132__t3 \$132 16.7641747213
* device instance _132_t4 r0 *1 0,0
R_132_t4 \$132__t4 \$132 9.52844849363
* device instance _132 r0 *1 0,0
C_132 \$132 vsubs 7.83841e-16
* device instance _135_t0 r0 *1 0,0
R_135_t0 \$135__t0 \$135 17.162141452
* device instance _135_t1 r0 *1 0,0
R_135_t1 \$135__t1 \$135 14.0706287935
* device instance _135_t2 r0 *1 0,0
R_135_t2 \$135__t2 \$135 13.6875065396
* device instance _135_t3 r0 *1 0,0
R_135_t3 \$135__t3 \$135 16.7641747213
* device instance _135_t4 r0 *1 0,0
R_135_t4 \$135__t4 \$135 9.52844849363
* device instance _135 r0 *1 0,0
C_135 \$135 vsubs 7.83841e-16
* device instance _138_t0 r0 *1 0,0
R_138_t0 \$138__t0 \$138 17.162141452
* device instance _138_t1 r0 *1 0,0
R_138_t1 \$138__t1 \$138 14.0706287935
* device instance _138_t2 r0 *1 0,0
R_138_t2 \$138__t2 \$138 13.6875065396
* device instance _138_t3 r0 *1 0,0
R_138_t3 \$138__t3 \$138 16.7641747213
* device instance _138_t4 r0 *1 0,0
R_138_t4 \$138__t4 \$138 9.52844849363
* device instance _138 r0 *1 0,0
C_138 \$138 vsubs 7.83841e-16
* device instance _14_t0 r0 *1 0,0
R_14_t0 \$14__t0 \$14 14.0706287935
* device instance _14_t1 r0 *1 0,0
R_14_t1 \$14__t1 \$14 17.162141452
* device instance _14_t2 r0 *1 0,0
R_14_t2 \$14__t2 \$14 13.6875065396
* device instance _14_t3 r0 *1 0,0
R_14_t3 \$14__t3 \$14 9.52844849363
* device instance _14_t4 r0 *1 0,0
R_14_t4 \$14__t4 \$14 16.7641747213
* device instance _14 r0 *1 0,0
C_14 \$14 vsubs 7.92193e-16
* device instance _141_t0 r0 *1 0,0
R_141_t0 \$141__t0 \$141 17.162141452
* device instance _141_t1 r0 *1 0,0
R_141_t1 \$141__t1 \$141 14.0706287935
* device instance _141_t2 r0 *1 0,0
R_141_t2 \$141__t2 \$141 13.6875065396
* device instance _141_t3 r0 *1 0,0
R_141_t3 \$141__t3 \$141 16.7641747213
* device instance _141_t4 r0 *1 0,0
R_141_t4 \$141__t4 \$141 9.52844849363
* device instance _141 r0 *1 0,0
C_141 \$141 vsubs 7.83841e-16
* device instance _144_t0 r0 *1 0,0
R_144_t0 \$144__t0 \$144 17.162141452
* device instance _144_t1 r0 *1 0,0
R_144_t1 \$144__t1 \$144 14.0706287935
* device instance _144_t2 r0 *1 0,0
R_144_t2 \$144__t2 \$144 13.6875065396
* device instance _144_t3 r0 *1 0,0
R_144_t3 \$144__t3 \$144 16.7641747213
* device instance _144_t4 r0 *1 0,0
R_144_t4 \$144__t4 \$144 9.52844849363
* device instance _144 r0 *1 0,0
C_144 \$144 vsubs 7.83841e-16
* device instance _147_t0 r0 *1 0,0
R_147_t0 \$147__t0 \$147 17.162141452
* device instance _147_t1 r0 *1 0,0
R_147_t1 \$147__t1 \$147 14.0706287935
* device instance _147_t2 r0 *1 0,0
R_147_t2 \$147__t2 \$147 13.6875065396
* device instance _147_t3 r0 *1 0,0
R_147_t3 \$147__t3 \$147 16.7641747213
* device instance _147_t4 r0 *1 0,0
R_147_t4 \$147__t4 \$147 9.52844849363
* device instance _147 r0 *1 0,0
C_147 \$147 vsubs 7.83841e-16
* device instance _15_t0 r0 *1 0,0
R_15_t0 \$15__t0 \$15 14.0706287935
* device instance _15_t1 r0 *1 0,0
R_15_t1 \$15__t1 \$15 17.162141452
* device instance _15_t2 r0 *1 0,0
R_15_t2 \$15__t2 \$15 13.6875065396
* device instance _15_t3 r0 *1 0,0
R_15_t3 \$15__t3 \$15 9.52844849363
* device instance _15_t4 r0 *1 0,0
R_15_t4 \$15__t4 \$15 16.7641747213
* device instance _15 r0 *1 0,0
C_15 \$15 vsubs 7.92193e-16
* device instance _150_t0 r0 *1 0,0
R_150_t0 \$150__t0 \$150 17.162141452
* device instance _150_t1 r0 *1 0,0
R_150_t1 \$150__t1 \$150 14.0706287935
* device instance _150_t2 r0 *1 0,0
R_150_t2 \$150__t2 \$150 13.6875065396
* device instance _150_t3 r0 *1 0,0
R_150_t3 \$150__t3 \$150 16.7641747213
* device instance _150_t4 r0 *1 0,0
R_150_t4 \$150__t4 \$150 9.52844849363
* device instance _150 r0 *1 0,0
C_150 \$150 vsubs 7.83841e-16
* device instance _153_t0 r0 *1 0,0
R_153_t0 \$153__t0 \$153 17.162141452
* device instance _153_t1 r0 *1 0,0
R_153_t1 \$153__t1 \$153 14.0706287935
* device instance _153_t2 r0 *1 0,0
R_153_t2 \$153__t2 \$153 13.6875065396
* device instance _153_t3 r0 *1 0,0
R_153_t3 \$153__t3 \$153 16.7641747213
* device instance _153_t4 r0 *1 0,0
R_153_t4 \$153__t4 \$153 9.52844849363
* device instance _153 r0 *1 0,0
C_153 \$153 vsubs 7.83841e-16
* device instance _156_t0 r0 *1 0,0
R_156_t0 \$156__t0 \$156 17.162141452
* device instance _156_t1 r0 *1 0,0
R_156_t1 \$156__t1 \$156 14.0706287935
* device instance _156_t2 r0 *1 0,0
R_156_t2 \$156__t2 \$156 13.6875065396
* device instance _156_t3 r0 *1 0,0
R_156_t3 \$156__t3 \$156 16.7641747213
* device instance _156_t4 r0 *1 0,0
R_156_t4 \$156__t4 \$156 9.52844849363
* device instance _156 r0 *1 0,0
C_156 \$156 vsubs 7.83841e-16
* device instance _159_t0 r0 *1 0,0
R_159_t0 \$159__t0 \$159 17.162141452
* device instance _159_t1 r0 *1 0,0
R_159_t1 \$159__t1 \$159 14.0706287935
* device instance _159_t2 r0 *1 0,0
R_159_t2 \$159__t2 \$159 13.6875065396
* device instance _159_t3 r0 *1 0,0
R_159_t3 \$159__t3 \$159 16.7641747213
* device instance _159_t4 r0 *1 0,0
R_159_t4 \$159__t4 \$159 9.52844849363
* device instance _159 r0 *1 0,0
C_159 \$159 vsubs 7.83841e-16
* device instance _16_t0 r0 *1 0,0
R_16_t0 \$16__t0 \$16 14.0706287935
* device instance _16_t1 r0 *1 0,0
R_16_t1 \$16__t1 \$16 17.162141452
* device instance _16_t2 r0 *1 0,0
R_16_t2 \$16__t2 \$16 13.6875065396
* device instance _16_t3 r0 *1 0,0
R_16_t3 \$16__t3 \$16 9.52844849363
* device instance _16_t4 r0 *1 0,0
R_16_t4 \$16__t4 \$16 16.7641747213
* device instance _16 r0 *1 0,0
C_16 \$16 vsubs 7.92193e-16
* device instance _162_t0 r0 *1 0,0
R_162_t0 \$162__t0 \$162 17.162141452
* device instance _162_t1 r0 *1 0,0
R_162_t1 \$162__t1 \$162 14.0706287935
* device instance _162_t2 r0 *1 0,0
R_162_t2 \$162__t2 \$162 13.6875065396
* device instance _162_t3 r0 *1 0,0
R_162_t3 \$162__t3 \$162 16.7641747213
* device instance _162_t4 r0 *1 0,0
R_162_t4 \$162__t4 \$162 9.52844849363
* device instance _162 r0 *1 0,0
C_162 \$162 vsubs 7.83841e-16
* device instance _165_t0 r0 *1 0,0
R_165_t0 \$165__t0 \$165 17.162141452
* device instance _165_t1 r0 *1 0,0
R_165_t1 \$165__t1 \$165 14.0706287935
* device instance _165_t2 r0 *1 0,0
R_165_t2 \$165__t2 \$165 13.6875065396
* device instance _165_t3 r0 *1 0,0
R_165_t3 \$165__t3 \$165 16.7641747213
* device instance _165_t4 r0 *1 0,0
R_165_t4 \$165__t4 \$165 9.52844849363
* device instance _165 r0 *1 0,0
C_165 \$165 vsubs 7.83841e-16
* device instance _168_t0 r0 *1 0,0
R_168_t0 \$168__t0 \$168 17.162141452
* device instance _168_t1 r0 *1 0,0
R_168_t1 \$168__t1 \$168 14.0706287935
* device instance _168_t2 r0 *1 0,0
R_168_t2 \$168__t2 \$168 13.6875065396
* device instance _168_t3 r0 *1 0,0
R_168_t3 \$168__t3 \$168 16.7641747213
* device instance _168_t4 r0 *1 0,0
R_168_t4 \$168__t4 \$168 9.52844849363
* device instance _168 r0 *1 0,0
C_168 \$168 vsubs 7.83841e-16
* device instance _17_t0 r0 *1 0,0
R_17_t0 \$17__t0 \$17 14.0706287935
* device instance _17_t1 r0 *1 0,0
R_17_t1 \$17__t1 \$17 17.162141452
* device instance _17_t2 r0 *1 0,0
R_17_t2 \$17__t2 \$17 13.6875065396
* device instance _17_t3 r0 *1 0,0
R_17_t3 \$17__t3 \$17 9.52844849363
* device instance _17_t4 r0 *1 0,0
R_17_t4 \$17__t4 \$17 16.7641747213
* device instance _17 r0 *1 0,0
C_17 \$17 vsubs 7.92193e-16
* device instance _171_t0 r0 *1 0,0
R_171_t0 \$171__t0 \$171 17.162141452
* device instance _171_t1 r0 *1 0,0
R_171_t1 \$171__t1 \$171 14.0706287935
* device instance _171_t2 r0 *1 0,0
R_171_t2 \$171__t2 \$171 13.6875065396
* device instance _171_t3 r0 *1 0,0
R_171_t3 \$171__t3 \$171 16.7641747213
* device instance _171_t4 r0 *1 0,0
R_171_t4 \$171__t4 \$171 9.52844849363
* device instance _171 r0 *1 0,0
C_171 \$171 vsubs 7.83841e-16
* device instance _174_t0 r0 *1 0,0
R_174_t0 \$174__t0 \$174 17.162141452
* device instance _174_t1 r0 *1 0,0
R_174_t1 \$174__t1 \$174 14.0706287935
* device instance _174_t2 r0 *1 0,0
R_174_t2 \$174__t2 \$174 13.6875065396
* device instance _174_t3 r0 *1 0,0
R_174_t3 \$174__t3 \$174 16.7641747213
* device instance _174_t4 r0 *1 0,0
R_174_t4 \$174__t4 \$174 9.52844849363
* device instance _174 r0 *1 0,0
C_174 \$174 vsubs 7.83841e-16
* device instance _177_t0 r0 *1 0,0
R_177_t0 \$177__t0 \$177 17.162141452
* device instance _177_t1 r0 *1 0,0
R_177_t1 \$177__t1 \$177 14.0706287935
* device instance _177_t2 r0 *1 0,0
R_177_t2 \$177__t2 \$177 13.6875065396
* device instance _177_t3 r0 *1 0,0
R_177_t3 \$177__t3 \$177 16.7641747213
* device instance _177_t4 r0 *1 0,0
R_177_t4 \$177__t4 \$177 9.52844849363
* device instance _177 r0 *1 0,0
C_177 \$177 vsubs 7.83841e-16
* device instance _18_t0 r0 *1 0,0
R_18_t0 \$18__t0 \$18 14.0706287935
* device instance _18_t1 r0 *1 0,0
R_18_t1 \$18__t1 \$18 17.162141452
* device instance _18_t2 r0 *1 0,0
R_18_t2 \$18__t2 \$18 13.6875065396
* device instance _18_t3 r0 *1 0,0
R_18_t3 \$18__t3 \$18 9.52844849363
* device instance _18_t4 r0 *1 0,0
R_18_t4 \$18__t4 \$18 16.7641747213
* device instance _18 r0 *1 0,0
C_18 \$18 vsubs 7.92193e-16
* device instance _180_t0 r0 *1 0,0
R_180_t0 \$180__t0 \$180 17.162141452
* device instance _180_t1 r0 *1 0,0
R_180_t1 \$180__t1 \$180 14.0706287935
* device instance _180_t2 r0 *1 0,0
R_180_t2 \$180__t2 \$180 13.6875065396
* device instance _180_t3 r0 *1 0,0
R_180_t3 \$180__t3 \$180 16.7641747213
* device instance _180_t4 r0 *1 0,0
R_180_t4 \$180__t4 \$180 9.52844849363
* device instance _180 r0 *1 0,0
C_180 \$180 vsubs 7.83841e-16
* device instance _183_t0 r0 *1 0,0
R_183_t0 \$183__t0 \$183 17.162141452
* device instance _183_t1 r0 *1 0,0
R_183_t1 \$183__t1 \$183 14.0706287935
* device instance _183_t2 r0 *1 0,0
R_183_t2 \$183__t2 \$183 13.6875065396
* device instance _183_t3 r0 *1 0,0
R_183_t3 \$183__t3 \$183 16.7641747213
* device instance _183_t4 r0 *1 0,0
R_183_t4 \$183__t4 \$183 9.52844849363
* device instance _183 r0 *1 0,0
C_183 \$183 vsubs 7.83841e-16
* device instance _186_t0 r0 *1 0,0
R_186_t0 \$186__t0 \$186 17.162141452
* device instance _186_t1 r0 *1 0,0
R_186_t1 \$186__t1 \$186 14.0706287935
* device instance _186_t2 r0 *1 0,0
R_186_t2 \$186__t2 \$186 13.6875065396
* device instance _186_t3 r0 *1 0,0
R_186_t3 \$186__t3 \$186 16.7641747213
* device instance _186_t4 r0 *1 0,0
R_186_t4 \$186__t4 \$186 9.52844849363
* device instance _186 r0 *1 0,0
C_186 \$186 vsubs 7.83841e-16
* device instance _189_t0 r0 *1 0,0
R_189_t0 \$189__t0 \$189 17.162141452
* device instance _189_t1 r0 *1 0,0
R_189_t1 \$189__t1 \$189 14.0706287935
* device instance _189_t2 r0 *1 0,0
R_189_t2 \$189__t2 \$189 13.6875065396
* device instance _189_t3 r0 *1 0,0
R_189_t3 \$189__t3 \$189 16.7641747213
* device instance _189_t4 r0 *1 0,0
R_189_t4 \$189__t4 \$189 9.52844849363
* device instance _189 r0 *1 0,0
C_189 \$189 vsubs 7.83841e-16
* device instance _19_t0 r0 *1 0,0
R_19_t0 \$19__t0 \$19 14.0706287935
* device instance _19_t1 r0 *1 0,0
R_19_t1 \$19__t1 \$19 17.162141452
* device instance _19_t2 r0 *1 0,0
R_19_t2 \$19__t2 \$19 13.6875065396
* device instance _19_t3 r0 *1 0,0
R_19_t3 \$19__t3 \$19 9.52844849363
* device instance _19_t4 r0 *1 0,0
R_19_t4 \$19__t4 \$19 16.7641747213
* device instance _19 r0 *1 0,0
C_19 \$19 vsubs 7.92193e-16
* device instance _192_t0 r0 *1 0,0
R_192_t0 \$192__t0 \$192 17.162141452
* device instance _192_t1 r0 *1 0,0
R_192_t1 \$192__t1 \$192 14.0706287935
* device instance _192_t2 r0 *1 0,0
R_192_t2 \$192__t2 \$192 13.6875065396
* device instance _192_t3 r0 *1 0,0
R_192_t3 \$192__t3 \$192 16.7641747213
* device instance _192_t4 r0 *1 0,0
R_192_t4 \$192__t4 \$192 9.52844849363
* device instance _192 r0 *1 0,0
C_192 \$192 vsubs 7.83841e-16
* device instance _195_t0 r0 *1 0,0
R_195_t0 \$195__t0 \$195 17.162141452
* device instance _195_t1 r0 *1 0,0
R_195_t1 \$195__t1 \$195 14.0706287935
* device instance _195_t2 r0 *1 0,0
R_195_t2 \$195__t2 \$195 13.6875065396
* device instance _195_t3 r0 *1 0,0
R_195_t3 \$195__t3 \$195 16.7641747213
* device instance _195_t4 r0 *1 0,0
R_195_t4 \$195__t4 \$195 9.52844849363
* device instance _195 r0 *1 0,0
C_195 \$195 vsubs 7.83841e-16
* device instance _198_t0 r0 *1 0,0
R_198_t0 \$198__t0 \$198 17.162141452
* device instance _198_t1 r0 *1 0,0
R_198_t1 \$198__t1 \$198 14.0706287935
* device instance _198_t2 r0 *1 0,0
R_198_t2 \$198__t2 \$198 13.6875065396
* device instance _198_t3 r0 *1 0,0
R_198_t3 \$198__t3 \$198 16.7641747213
* device instance _198_t4 r0 *1 0,0
R_198_t4 \$198__t4 \$198 9.52844849363
* device instance _198 r0 *1 0,0
C_198 \$198 vsubs 7.83841e-16
* device instance _20_t0 r0 *1 0,0
R_20_t0 \$20__t0 \$20 14.0706287935
* device instance _20_t1 r0 *1 0,0
R_20_t1 \$20__t1 \$20 17.162141452
* device instance _20_t2 r0 *1 0,0
R_20_t2 \$20__t2 \$20 13.6875065396
* device instance _20_t3 r0 *1 0,0
R_20_t3 \$20__t3 \$20 9.52844849363
* device instance _20_t4 r0 *1 0,0
R_20_t4 \$20__t4 \$20 16.7641747213
* device instance _20 r0 *1 0,0
C_20 \$20 vsubs 7.92193e-16
* device instance _201_t0 r0 *1 0,0
R_201_t0 \$201__t0 \$201 17.162141452
* device instance _201_t1 r0 *1 0,0
R_201_t1 \$201__t1 \$201 14.0706287935
* device instance _201_t2 r0 *1 0,0
R_201_t2 \$201__t2 \$201 13.6875065396
* device instance _201_t3 r0 *1 0,0
R_201_t3 \$201__t3 \$201 16.7641747213
* device instance _201_t4 r0 *1 0,0
R_201_t4 \$201__t4 \$201 9.52844849363
* device instance _201 r0 *1 0,0
C_201 \$201 vsubs 7.83841e-16
* device instance _204_t0 r0 *1 0,0
R_204_t0 \$204__t0 \$204 17.162141452
* device instance _204_t1 r0 *1 0,0
R_204_t1 \$204__t1 \$204 14.0706287935
* device instance _204_t2 r0 *1 0,0
R_204_t2 \$204__t2 \$204 13.6875065396
* device instance _204_t3 r0 *1 0,0
R_204_t3 \$204__t3 \$204 16.7641747213
* device instance _204_t4 r0 *1 0,0
R_204_t4 \$204__t4 \$204 9.52844849363
* device instance _204 r0 *1 0,0
C_204 \$204 vsubs 7.83841e-16
* device instance _207_t0 r0 *1 0,0
R_207_t0 \$207__t0 \$207 17.162141452
* device instance _207_t1 r0 *1 0,0
R_207_t1 \$207__t1 \$207 14.0706287935
* device instance _207_t2 r0 *1 0,0
R_207_t2 \$207__t2 \$207 13.6875065396
* device instance _207_t3 r0 *1 0,0
R_207_t3 \$207__t3 \$207 16.7641747213
* device instance _207_t4 r0 *1 0,0
R_207_t4 \$207__t4 \$207 9.52844849363
* device instance _207 r0 *1 0,0
C_207 \$207 vsubs 7.83841e-16
* device instance _21_t0 r0 *1 0,0
R_21_t0 \$21__t0 \$21 14.0706287935
* device instance _21_t1 r0 *1 0,0
R_21_t1 \$21__t1 \$21 17.162141452
* device instance _21_t2 r0 *1 0,0
R_21_t2 \$21__t2 \$21 13.6875065396
* device instance _21_t3 r0 *1 0,0
R_21_t3 \$21__t3 \$21 9.52844849363
* device instance _21_t4 r0 *1 0,0
R_21_t4 \$21__t4 \$21 16.7641747213
* device instance _21 r0 *1 0,0
C_21 \$21 vsubs 7.92193e-16
* device instance _210_t0 r0 *1 0,0
R_210_t0 \$210__t0 \$210 17.162141452
* device instance _210_t1 r0 *1 0,0
R_210_t1 \$210__t1 \$210 14.0706287935
* device instance _210_t2 r0 *1 0,0
R_210_t2 \$210__t2 \$210 13.6875065396
* device instance _210_t3 r0 *1 0,0
R_210_t3 \$210__t3 \$210 16.7641747213
* device instance _210_t4 r0 *1 0,0
R_210_t4 \$210__t4 \$210 9.52844849363
* device instance _210 r0 *1 0,0
C_210 \$210 vsubs 7.83841e-16
* device instance _213_t0 r0 *1 0,0
R_213_t0 \$213__t0 \$213 17.162141452
* device instance _213_t1 r0 *1 0,0
R_213_t1 \$213__t1 \$213 14.0706287935
* device instance _213_t2 r0 *1 0,0
R_213_t2 \$213__t2 \$213 13.6875065396
* device instance _213_t3 r0 *1 0,0
R_213_t3 \$213__t3 \$213 16.7641747213
* device instance _213_t4 r0 *1 0,0
R_213_t4 \$213__t4 \$213 9.52844849363
* device instance _213 r0 *1 0,0
C_213 \$213 vsubs 7.83841e-16
* device instance _216_t0 r0 *1 0,0
R_216_t0 \$216__t0 \$216 17.162141452
* device instance _216_t1 r0 *1 0,0
R_216_t1 \$216__t1 \$216 14.0706287935
* device instance _216_t2 r0 *1 0,0
R_216_t2 \$216__t2 \$216 13.6875065396
* device instance _216_t3 r0 *1 0,0
R_216_t3 \$216__t3 \$216 16.7641747213
* device instance _216_t4 r0 *1 0,0
R_216_t4 \$216__t4 \$216 9.52844849363
* device instance _216 r0 *1 0,0
C_216 \$216 vsubs 7.83841e-16
* device instance _219_t0 r0 *1 0,0
R_219_t0 \$219__t0 \$219 17.162141452
* device instance _219_t1 r0 *1 0,0
R_219_t1 \$219__t1 \$219 14.0706287935
* device instance _219_t2 r0 *1 0,0
R_219_t2 \$219__t2 \$219 13.6875065396
* device instance _219_t3 r0 *1 0,0
R_219_t3 \$219__t3 \$219 16.7641747213
* device instance _219_t4 r0 *1 0,0
R_219_t4 \$219__t4 \$219 9.52844849363
* device instance _219 r0 *1 0,0
C_219 \$219 vsubs 7.83841e-16
* device instance _22_t0 r0 *1 0,0
R_22_t0 \$22__t0 \$22 14.0706287935
* device instance _22_t1 r0 *1 0,0
R_22_t1 \$22__t1 \$22 17.162141452
* device instance _22_t2 r0 *1 0,0
R_22_t2 \$22__t2 \$22 13.6875065396
* device instance _22_t3 r0 *1 0,0
R_22_t3 \$22__t3 \$22 9.52844849363
* device instance _22_t4 r0 *1 0,0
R_22_t4 \$22__t4 \$22 16.7641747213
* device instance _22 r0 *1 0,0
C_22 \$22 vsubs 7.92193e-16
* device instance _222_t0 r0 *1 0,0
R_222_t0 \$222__t0 \$222 17.162141452
* device instance _222_t1 r0 *1 0,0
R_222_t1 \$222__t1 \$222 14.0706287935
* device instance _222_t2 r0 *1 0,0
R_222_t2 \$222__t2 \$222 13.6875065396
* device instance _222_t3 r0 *1 0,0
R_222_t3 \$222__t3 \$222 16.7641747213
* device instance _222_t4 r0 *1 0,0
R_222_t4 \$222__t4 \$222 9.52844849363
* device instance _222 r0 *1 0,0
C_222 \$222 vsubs 7.83841e-16
* device instance _225_t0 r0 *1 0,0
R_225_t0 \$225__t0 \$225 17.162141452
* device instance _225_t1 r0 *1 0,0
R_225_t1 \$225__t1 \$225 14.0706287935
* device instance _225_t2 r0 *1 0,0
R_225_t2 \$225__t2 \$225 13.6875065396
* device instance _225_t3 r0 *1 0,0
R_225_t3 \$225__t3 \$225 16.7641747213
* device instance _225_t4 r0 *1 0,0
R_225_t4 \$225__t4 \$225 9.52844849363
* device instance _225 r0 *1 0,0
C_225 \$225 vsubs 7.83841e-16
* device instance _228_t0 r0 *1 0,0
R_228_t0 \$228__t0 \$228 17.162141452
* device instance _228_t1 r0 *1 0,0
R_228_t1 \$228__t1 \$228 14.0706287935
* device instance _228_t2 r0 *1 0,0
R_228_t2 \$228__t2 \$228 13.6875065396
* device instance _228_t3 r0 *1 0,0
R_228_t3 \$228__t3 \$228 16.7641747213
* device instance _228_t4 r0 *1 0,0
R_228_t4 \$228__t4 \$228 9.52844849363
* device instance _228 r0 *1 0,0
C_228 \$228 vsubs 7.83841e-16
* device instance _23_t0 r0 *1 0,0
R_23_t0 \$23__t0 \$23 14.0706287935
* device instance _23_t1 r0 *1 0,0
R_23_t1 \$23__t1 \$23 17.162141452
* device instance _23_t2 r0 *1 0,0
R_23_t2 \$23__t2 \$23 13.6875065396
* device instance _23_t3 r0 *1 0,0
R_23_t3 \$23__t3 \$23 9.52844849363
* device instance _23_t4 r0 *1 0,0
R_23_t4 \$23__t4 \$23 16.7641747213
* device instance _23 r0 *1 0,0
C_23 \$23 vsubs 7.92193e-16
* device instance _231_t0 r0 *1 0,0
R_231_t0 \$231__t0 \$231 17.162141452
* device instance _231_t1 r0 *1 0,0
R_231_t1 \$231__t1 \$231 14.0706287935
* device instance _231_t2 r0 *1 0,0
R_231_t2 \$231__t2 \$231 13.6875065396
* device instance _231_t3 r0 *1 0,0
R_231_t3 \$231__t3 \$231 16.7641747213
* device instance _231_t4 r0 *1 0,0
R_231_t4 \$231__t4 \$231 9.52844849363
* device instance _231 r0 *1 0,0
C_231 \$231 vsubs 7.83841e-16
* device instance _234_t0 r0 *1 0,0
R_234_t0 \$234__t0 \$234 17.162141452
* device instance _234_t1 r0 *1 0,0
R_234_t1 \$234__t1 \$234 14.0706287935
* device instance _234_t2 r0 *1 0,0
R_234_t2 \$234__t2 \$234 13.6875065396
* device instance _234_t3 r0 *1 0,0
R_234_t3 \$234__t3 \$234 16.7641747213
* device instance _234_t4 r0 *1 0,0
R_234_t4 \$234__t4 \$234 9.52844849363
* device instance _234 r0 *1 0,0
C_234 \$234 vsubs 7.83841e-16
* device instance _237_t0 r0 *1 0,0
R_237_t0 \$237__t0 \$237 17.162141452
* device instance _237_t1 r0 *1 0,0
R_237_t1 \$237__t1 \$237 14.0706287935
* device instance _237_t2 r0 *1 0,0
R_237_t2 \$237__t2 \$237 13.6875065396
* device instance _237_t3 r0 *1 0,0
R_237_t3 \$237__t3 \$237 16.7641747213
* device instance _237_t4 r0 *1 0,0
R_237_t4 \$237__t4 \$237 9.52844849363
* device instance _237 r0 *1 0,0
C_237 \$237 vsubs 7.83841e-16
* device instance _24_t0 r0 *1 0,0
R_24_t0 \$24__t0 \$24 14.0706287935
* device instance _24_t1 r0 *1 0,0
R_24_t1 \$24__t1 \$24 17.162141452
* device instance _24_t2 r0 *1 0,0
R_24_t2 \$24__t2 \$24 13.6875065396
* device instance _24_t3 r0 *1 0,0
R_24_t3 \$24__t3 \$24 9.52844849363
* device instance _24_t4 r0 *1 0,0
R_24_t4 \$24__t4 \$24 16.7641747213
* device instance _24 r0 *1 0,0
C_24 \$24 vsubs 7.92193e-16
* device instance _240_t0 r0 *1 0,0
R_240_t0 \$240__t0 \$240 17.162141452
* device instance _240_t1 r0 *1 0,0
R_240_t1 \$240__t1 \$240 14.0706287935
* device instance _240_t2 r0 *1 0,0
R_240_t2 \$240__t2 \$240 13.6875065396
* device instance _240_t3 r0 *1 0,0
R_240_t3 \$240__t3 \$240 16.7641747213
* device instance _240_t4 r0 *1 0,0
R_240_t4 \$240__t4 \$240 9.52844849363
* device instance _240 r0 *1 0,0
C_240 \$240 vsubs 7.83841e-16
* device instance _243_t0 r0 *1 0,0
R_243_t0 \$243__t0 \$243 17.162141452
* device instance _243_t1 r0 *1 0,0
R_243_t1 \$243__t1 \$243 14.0706287935
* device instance _243_t2 r0 *1 0,0
R_243_t2 \$243__t2 \$243 13.6875065396
* device instance _243_t3 r0 *1 0,0
R_243_t3 \$243__t3 \$243 16.7641747213
* device instance _243_t4 r0 *1 0,0
R_243_t4 \$243__t4 \$243 9.52844849363
* device instance _243 r0 *1 0,0
C_243 \$243 vsubs 7.83841e-16
* device instance _246_t0 r0 *1 0,0
R_246_t0 \$246__t0 \$246 17.162141452
* device instance _246_t1 r0 *1 0,0
R_246_t1 \$246__t1 \$246 14.0706287935
* device instance _246_t2 r0 *1 0,0
R_246_t2 \$246__t2 \$246 13.6875065396
* device instance _246_t3 r0 *1 0,0
R_246_t3 \$246__t3 \$246 16.7641747213
* device instance _246_t4 r0 *1 0,0
R_246_t4 \$246__t4 \$246 9.52844849363
* device instance _246 r0 *1 0,0
C_246 \$246 vsubs 7.83841e-16
* device instance _249_t0 r0 *1 0,0
R_249_t0 \$249__t0 \$249 17.162141452
* device instance _249_t1 r0 *1 0,0
R_249_t1 \$249__t1 \$249 14.0706287935
* device instance _249_t2 r0 *1 0,0
R_249_t2 \$249__t2 \$249 13.6875065396
* device instance _249_t3 r0 *1 0,0
R_249_t3 \$249__t3 \$249 16.7641747213
* device instance _249_t4 r0 *1 0,0
R_249_t4 \$249__t4 \$249 9.52844849363
* device instance _249 r0 *1 0,0
C_249 \$249 vsubs 7.83841e-16
* device instance _25_t0 r0 *1 0,0
R_25_t0 \$25__t0 \$25 14.0706287935
* device instance _25_t1 r0 *1 0,0
R_25_t1 \$25__t1 \$25 17.162141452
* device instance _25_t2 r0 *1 0,0
R_25_t2 \$25__t2 \$25 13.6875065396
* device instance _25_t3 r0 *1 0,0
R_25_t3 \$25__t3 \$25 9.52844849363
* device instance _25_t4 r0 *1 0,0
R_25_t4 \$25__t4 \$25 16.7641747213
* device instance _25 r0 *1 0,0
C_25 \$25 vsubs 7.92193e-16
* device instance _252_t0 r0 *1 0,0
R_252_t0 \$252__t0 \$252 17.162141452
* device instance _252_t1 r0 *1 0,0
R_252_t1 \$252__t1 \$252 14.0706287935
* device instance _252_t2 r0 *1 0,0
R_252_t2 \$252__t2 \$252 13.6875065396
* device instance _252_t3 r0 *1 0,0
R_252_t3 \$252__t3 \$252 16.7641747213
* device instance _252_t4 r0 *1 0,0
R_252_t4 \$252__t4 \$252 9.52844849363
* device instance _252 r0 *1 0,0
C_252 \$252 vsubs 7.83841e-16
* device instance _255_t0 r0 *1 0,0
R_255_t0 \$255__t0 \$255 17.162141452
* device instance _255_t1 r0 *1 0,0
R_255_t1 \$255__t1 \$255 14.0706287935
* device instance _255_t2 r0 *1 0,0
R_255_t2 \$255__t2 \$255 13.6875065396
* device instance _255_t3 r0 *1 0,0
R_255_t3 \$255__t3 \$255 16.7641747213
* device instance _255_t4 r0 *1 0,0
R_255_t4 \$255__t4 \$255 9.52844849363
* device instance _255 r0 *1 0,0
C_255 \$255 vsubs 7.83841e-16
* device instance _258_t0 r0 *1 0,0
R_258_t0 \$258__t0 \$258 17.162141452
* device instance _258_t1 r0 *1 0,0
R_258_t1 \$258__t1 \$258 14.0706287935
* device instance _258_t2 r0 *1 0,0
R_258_t2 \$258__t2 \$258 13.6875065396
* device instance _258_t3 r0 *1 0,0
R_258_t3 \$258__t3 \$258 16.7641747213
* device instance _258_t4 r0 *1 0,0
R_258_t4 \$258__t4 \$258 9.52844849363
* device instance _258 r0 *1 0,0
C_258 \$258 vsubs 7.83841e-16
* device instance _26_t0 r0 *1 0,0
R_26_t0 \$26__t0 \$26 14.0706287935
* device instance _26_t1 r0 *1 0,0
R_26_t1 \$26__t1 \$26 17.162141452
* device instance _26_t2 r0 *1 0,0
R_26_t2 \$26__t2 \$26 13.6875065396
* device instance _26_t3 r0 *1 0,0
R_26_t3 \$26__t3 \$26 9.52844849363
* device instance _26_t4 r0 *1 0,0
R_26_t4 \$26__t4 \$26 16.7641747213
* device instance _26 r0 *1 0,0
C_26 \$26 vsubs 7.92193e-16
* device instance _27_t0 r0 *1 0,0
R_27_t0 \$27__t0 \$27 14.0706287935
* device instance _27_t1 r0 *1 0,0
R_27_t1 \$27__t1 \$27 17.162141452
* device instance _27_t2 r0 *1 0,0
R_27_t2 \$27__t2 \$27 13.6875065396
* device instance _27_t3 r0 *1 0,0
R_27_t3 \$27__t3 \$27 9.52844849363
* device instance _27_t4 r0 *1 0,0
R_27_t4 \$27__t4 \$27 16.7641747213
* device instance _27 r0 *1 0,0
C_27 \$27 vsubs 7.92193e-16
* device instance _28_t0 r0 *1 0,0
R_28_t0 \$28__t0 \$28 14.0706287935
* device instance _28_t1 r0 *1 0,0
R_28_t1 \$28__t1 \$28 17.162141452
* device instance _28_t2 r0 *1 0,0
R_28_t2 \$28__t2 \$28 13.6875065396
* device instance _28_t3 r0 *1 0,0
R_28_t3 \$28__t3 \$28 9.52844849363
* device instance _28_t4 r0 *1 0,0
R_28_t4 \$28__t4 \$28 16.7641747213
* device instance _28 r0 *1 0,0
C_28 \$28 vsubs 7.92193e-16
* device instance _29_t0 r0 *1 0,0
R_29_t0 \$29__t0 \$29 14.0706287935
* device instance _29_t1 r0 *1 0,0
R_29_t1 \$29__t1 \$29 17.162141452
* device instance _29_t2 r0 *1 0,0
R_29_t2 \$29__t2 \$29 13.6875065396
* device instance _29_t3 r0 *1 0,0
R_29_t3 \$29__t3 \$29 9.52844849363
* device instance _29_t4 r0 *1 0,0
R_29_t4 \$29__t4 \$29 16.7641747213
* device instance _29 r0 *1 0,0
C_29 \$29 vsubs 7.92193e-16
* device instance _30_t0 r0 *1 0,0
R_30_t0 \$30__t0 \$30 14.0706287935
* device instance _30_t1 r0 *1 0,0
R_30_t1 \$30__t1 \$30 17.162141452
* device instance _30_t2 r0 *1 0,0
R_30_t2 \$30__t2 \$30 13.6875065396
* device instance _30_t3 r0 *1 0,0
R_30_t3 \$30__t3 \$30 9.52844849363
* device instance _30_t4 r0 *1 0,0
R_30_t4 \$30__t4 \$30 16.7641747213
* device instance _30 r0 *1 0,0
C_30 \$30 vsubs 7.92193e-16
* device instance _31_t0 r0 *1 0,0
R_31_t0 \$31__t0 \$31 14.0706287935
* device instance _31_t1 r0 *1 0,0
R_31_t1 \$31__t1 \$31 17.162141452
* device instance _31_t2 r0 *1 0,0
R_31_t2 \$31__t2 \$31 13.6875065396
* device instance _31_t3 r0 *1 0,0
R_31_t3 \$31__t3 \$31 9.52844849363
* device instance _31_t4 r0 *1 0,0
R_31_t4 \$31__t4 \$31 16.7641747213
* device instance _31 r0 *1 0,0
C_31 \$31 vsubs 7.92193e-16
* device instance _32_t0 r0 *1 0,0
R_32_t0 \$32__t0 \$32 14.0706287935
* device instance _32_t1 r0 *1 0,0
R_32_t1 \$32__t1 \$32 17.162141452
* device instance _32_t2 r0 *1 0,0
R_32_t2 \$32__t2 \$32 13.6875065396
* device instance _32_t3 r0 *1 0,0
R_32_t3 \$32__t3 \$32 9.52844849363
* device instance _32_t4 r0 *1 0,0
R_32_t4 \$32__t4 \$32 16.7641747213
* device instance _32 r0 *1 0,0
C_32 \$32 vsubs 7.92193e-16
* device instance _33_t0 r0 *1 0,0
R_33_t0 \$33__t0 \$33 14.0706287935
* device instance _33_t1 r0 *1 0,0
R_33_t1 \$33__t1 \$33 17.162141452
* device instance _33_t2 r0 *1 0,0
R_33_t2 \$33__t2 \$33 13.6875065396
* device instance _33_t3 r0 *1 0,0
R_33_t3 \$33__t3 \$33 9.52844849363
* device instance _33_t4 r0 *1 0,0
R_33_t4 \$33__t4 \$33 16.7641747213
* device instance _33 r0 *1 0,0
C_33 \$33 vsubs 7.92193e-16
* device instance _34_t0 r0 *1 0,0
R_34_t0 \$34__t0 \$34 14.0706287935
* device instance _34_t1 r0 *1 0,0
R_34_t1 \$34__t1 \$34 17.162141452
* device instance _34_t2 r0 *1 0,0
R_34_t2 \$34__t2 \$34 13.6875065396
* device instance _34_t3 r0 *1 0,0
R_34_t3 \$34__t3 \$34 9.52844849363
* device instance _34_t4 r0 *1 0,0
R_34_t4 \$34__t4 \$34 16.7641747213
* device instance _34 r0 *1 0,0
C_34 \$34 vsubs 7.92193e-16
* device instance _35_t0 r0 *1 0,0
R_35_t0 \$35__t0 \$35 14.0706287935
* device instance _35_t1 r0 *1 0,0
R_35_t1 \$35__t1 \$35 17.162141452
* device instance _35_t2 r0 *1 0,0
R_35_t2 \$35__t2 \$35 13.6875065396
* device instance _35_t3 r0 *1 0,0
R_35_t3 \$35__t3 \$35 9.52844849363
* device instance _35_t4 r0 *1 0,0
R_35_t4 \$35__t4 \$35 16.7641747213
* device instance _35 r0 *1 0,0
C_35 \$35 vsubs 7.92193e-16
* device instance _36_t0 r0 *1 0,0
R_36_t0 \$36__t0 \$36 14.0706287935
* device instance _36_t1 r0 *1 0,0
R_36_t1 \$36__t1 \$36 17.162141452
* device instance _36_t2 r0 *1 0,0
R_36_t2 \$36__t2 \$36 13.6875065396
* device instance _36_t3 r0 *1 0,0
R_36_t3 \$36__t3 \$36 9.52844849363
* device instance _36_t4 r0 *1 0,0
R_36_t4 \$36__t4 \$36 16.7641747213
* device instance _36 r0 *1 0,0
C_36 \$36 vsubs 7.92193e-16
* device instance _37_t0 r0 *1 0,0
R_37_t0 \$37__t0 \$37 14.0706287935
* device instance _37_t1 r0 *1 0,0
R_37_t1 \$37__t1 \$37 17.162141452
* device instance _37_t2 r0 *1 0,0
R_37_t2 \$37__t2 \$37 13.6875065396
* device instance _37_t3 r0 *1 0,0
R_37_t3 \$37__t3 \$37 9.52844849363
* device instance _37_t4 r0 *1 0,0
R_37_t4 \$37__t4 \$37 16.7641747213
* device instance _37 r0 *1 0,0
C_37 \$37 vsubs 7.92193e-16
* device instance _38_t0 r0 *1 0,0
R_38_t0 \$38__t0 \$38 14.0706287935
* device instance _38_t1 r0 *1 0,0
R_38_t1 \$38__t1 \$38 17.162141452
* device instance _38_t2 r0 *1 0,0
R_38_t2 \$38__t2 \$38 13.6875065396
* device instance _38_t3 r0 *1 0,0
R_38_t3 \$38__t3 \$38 9.52844849363
* device instance _38_t4 r0 *1 0,0
R_38_t4 \$38__t4 \$38 16.7641747213
* device instance _38 r0 *1 0,0
C_38 \$38 vsubs 7.92193e-16
* device instance _39_t0 r0 *1 0,0
R_39_t0 \$39__t0 \$39 14.0706287935
* device instance _39_t1 r0 *1 0,0
R_39_t1 \$39__t1 \$39 17.162141452
* device instance _39_t2 r0 *1 0,0
R_39_t2 \$39__t2 \$39 13.6875065396
* device instance _39_t3 r0 *1 0,0
R_39_t3 \$39__t3 \$39 9.52844849363
* device instance _39_t4 r0 *1 0,0
R_39_t4 \$39__t4 \$39 16.7641747213
* device instance _39 r0 *1 0,0
C_39 \$39 vsubs 7.92193e-16
* device instance _4_t0 r0 *1 0,0
R_4_t0 \$4__t0 \$4 13.6875065396
* device instance _4_t1 r0 *1 0,0
R_4_t1 \$4__t1 \$4 17.162141452
* device instance _4_t2 r0 *1 0,0
R_4_t2 \$4__t2 \$4 14.0706287935
* device instance _4_t3 r0 *1 0,0
R_4_t3 \$4__t3 \$4 16.7641747213
* device instance _4_t4 r0 *1 0,0
R_4_t4 \$4__t4 \$4 9.52844849363
* device instance _4 r0 *1 0,0
C_4 \$4 vsubs 7.92193e-16
* device instance _40_t0 r0 *1 0,0
R_40_t0 \$40__t0 \$40 14.0706287935
* device instance _40_t1 r0 *1 0,0
R_40_t1 \$40__t1 \$40 17.162141452
* device instance _40_t2 r0 *1 0,0
R_40_t2 \$40__t2 \$40 13.6875065396
* device instance _40_t3 r0 *1 0,0
R_40_t3 \$40__t3 \$40 9.52844849363
* device instance _40_t4 r0 *1 0,0
R_40_t4 \$40__t4 \$40 16.7641747213
* device instance _40 r0 *1 0,0
C_40 \$40 vsubs 7.92193e-16
* device instance _41_t0 r0 *1 0,0
R_41_t0 \$41__t0 \$41 14.0706287935
* device instance _41_t1 r0 *1 0,0
R_41_t1 \$41__t1 \$41 17.162141452
* device instance _41_t2 r0 *1 0,0
R_41_t2 \$41__t2 \$41 13.6875065396
* device instance _41_t3 r0 *1 0,0
R_41_t3 \$41__t3 \$41 9.52844849363
* device instance _41_t4 r0 *1 0,0
R_41_t4 \$41__t4 \$41 16.7641747213
* device instance _41 r0 *1 0,0
C_41 \$41 vsubs 7.92193e-16
* device instance _42_t0 r0 *1 0,0
R_42_t0 \$42__t0 \$42 14.0706287935
* device instance _42_t1 r0 *1 0,0
R_42_t1 \$42__t1 \$42 17.162141452
* device instance _42_t2 r0 *1 0,0
R_42_t2 \$42__t2 \$42 13.6875065396
* device instance _42_t3 r0 *1 0,0
R_42_t3 \$42__t3 \$42 9.52844849363
* device instance _42_t4 r0 *1 0,0
R_42_t4 \$42__t4 \$42 16.7641747213
* device instance _42 r0 *1 0,0
C_42 \$42 vsubs 7.92193e-16
* device instance _43_t0 r0 *1 0,0
R_43_t0 \$43__t0 \$43 14.0706287935
* device instance _43_t1 r0 *1 0,0
R_43_t1 \$43__t1 \$43 17.162141452
* device instance _43_t2 r0 *1 0,0
R_43_t2 \$43__t2 \$43 13.6875065396
* device instance _43_t3 r0 *1 0,0
R_43_t3 \$43__t3 \$43 9.52844849363
* device instance _43_t4 r0 *1 0,0
R_43_t4 \$43__t4 \$43 16.7641747213
* device instance _43 r0 *1 0,0
C_43 \$43 vsubs 7.92193e-16
* device instance _44_t0 r0 *1 0,0
R_44_t0 \$44__t0 \$44 14.0706287935
* device instance _44_t1 r0 *1 0,0
R_44_t1 \$44__t1 \$44 17.162141452
* device instance _44_t2 r0 *1 0,0
R_44_t2 \$44__t2 \$44 13.6875065396
* device instance _44_t3 r0 *1 0,0
R_44_t3 \$44__t3 \$44 9.52844849363
* device instance _44_t4 r0 *1 0,0
R_44_t4 \$44__t4 \$44 16.7641747213
* device instance _44 r0 *1 0,0
C_44 \$44 vsubs 7.92193e-16
* device instance _45_t0 r0 *1 0,0
R_45_t0 \$45__t0 \$45 14.0706287935
* device instance _45_t1 r0 *1 0,0
R_45_t1 \$45__t1 \$45 17.162141452
* device instance _45_t2 r0 *1 0,0
R_45_t2 \$45__t2 \$45 13.6875065396
* device instance _45_t3 r0 *1 0,0
R_45_t3 \$45__t3 \$45 9.52844849363
* device instance _45_t4 r0 *1 0,0
R_45_t4 \$45__t4 \$45 16.7641747213
* device instance _45 r0 *1 0,0
C_45 \$45 vsubs 7.92193e-16
* device instance _46_t0 r0 *1 0,0
R_46_t0 \$46__t0 \$46 14.0706287935
* device instance _46_t1 r0 *1 0,0
R_46_t1 \$46__t1 \$46 17.162141452
* device instance _46_t2 r0 *1 0,0
R_46_t2 \$46__t2 \$46 13.6875065396
* device instance _46_t3 r0 *1 0,0
R_46_t3 \$46__t3 \$46 9.52844849363
* device instance _46_t4 r0 *1 0,0
R_46_t4 \$46__t4 \$46 16.7641747213
* device instance _46 r0 *1 0,0
C_46 \$46 vsubs 7.92193e-16
* device instance _47_t0 r0 *1 0,0
R_47_t0 \$47__t0 \$47 14.0706287935
* device instance _47_t1 r0 *1 0,0
R_47_t1 \$47__t1 \$47 17.162141452
* device instance _47_t2 r0 *1 0,0
R_47_t2 \$47__t2 \$47 13.6875065396
* device instance _47_t3 r0 *1 0,0
R_47_t3 \$47__t3 \$47 9.52844849363
* device instance _47_t4 r0 *1 0,0
R_47_t4 \$47__t4 \$47 16.7641747213
* device instance _47 r0 *1 0,0
C_47 \$47 vsubs 7.92193e-16
* device instance _48_t0 r0 *1 0,0
R_48_t0 \$48__t0 \$48 14.0706287935
* device instance _48_t1 r0 *1 0,0
R_48_t1 \$48__t1 \$48 17.162141452
* device instance _48_t2 r0 *1 0,0
R_48_t2 \$48__t2 \$48 13.6875065396
* device instance _48_t3 r0 *1 0,0
R_48_t3 \$48__t3 \$48 9.52844849363
* device instance _48_t4 r0 *1 0,0
R_48_t4 \$48__t4 \$48 16.7641747213
* device instance _48 r0 *1 0,0
C_48 \$48 vsubs 7.92193e-16
* device instance _49_t0 r0 *1 0,0
R_49_t0 \$49__t0 \$49 14.0706287935
* device instance _49_t1 r0 *1 0,0
R_49_t1 \$49__t1 \$49 17.162141452
* device instance _49_t2 r0 *1 0,0
R_49_t2 \$49__t2 \$49 13.6875065396
* device instance _49_t3 r0 *1 0,0
R_49_t3 \$49__t3 \$49 9.52844849363
* device instance _49_t4 r0 *1 0,0
R_49_t4 \$49__t4 \$49 16.7641747213
* device instance _49 r0 *1 0,0
C_49 \$49 vsubs 7.92193e-16
* device instance _5_t0 r0 *1 0,0
R_5_t0 \$5__t0 \$5 14.0706287935
* device instance _5_t1 r0 *1 0,0
R_5_t1 \$5__t1 \$5 17.162141452
* device instance _5_t2 r0 *1 0,0
R_5_t2 \$5__t2 \$5 13.6875065396
* device instance _5_t3 r0 *1 0,0
R_5_t3 \$5__t3 \$5 9.52844849363
* device instance _5_t4 r0 *1 0,0
R_5_t4 \$5__t4 \$5 16.7641747213
* device instance _5 r0 *1 0,0
C_5 \$5 vsubs 7.92193e-16
* device instance _50_t0 r0 *1 0,0
R_50_t0 \$50__t0 \$50 14.0706287935
* device instance _50_t1 r0 *1 0,0
R_50_t1 \$50__t1 \$50 17.162141452
* device instance _50_t2 r0 *1 0,0
R_50_t2 \$50__t2 \$50 13.6875065396
* device instance _50_t3 r0 *1 0,0
R_50_t3 \$50__t3 \$50 9.52844849363
* device instance _50_t4 r0 *1 0,0
R_50_t4 \$50__t4 \$50 16.7641747213
* device instance _50 r0 *1 0,0
C_50 \$50 vsubs 7.92193e-16
* device instance _51_t0 r0 *1 0,0
R_51_t0 \$51__t0 \$51 14.0706287935
* device instance _51_t1 r0 *1 0,0
R_51_t1 \$51__t1 \$51 17.162141452
* device instance _51_t2 r0 *1 0,0
R_51_t2 \$51__t2 \$51 13.6875065396
* device instance _51_t3 r0 *1 0,0
R_51_t3 \$51__t3 \$51 9.52844849363
* device instance _51_t4 r0 *1 0,0
R_51_t4 \$51__t4 \$51 16.7641747213
* device instance _51 r0 *1 0,0
C_51 \$51 vsubs 7.92193e-16
* device instance _52_t0 r0 *1 0,0
R_52_t0 \$52__t0 \$52 14.0706287935
* device instance _52_t1 r0 *1 0,0
R_52_t1 \$52__t1 \$52 17.162141452
* device instance _52_t2 r0 *1 0,0
R_52_t2 \$52__t2 \$52 13.6875065396
* device instance _52_t3 r0 *1 0,0
R_52_t3 \$52__t3 \$52 9.52844849363
* device instance _52_t4 r0 *1 0,0
R_52_t4 \$52__t4 \$52 16.7641747213
* device instance _52 r0 *1 0,0
C_52 \$52 vsubs 7.92193e-16
* device instance _53_t0 r0 *1 0,0
R_53_t0 \$53__t0 \$53 14.0706287935
* device instance _53_t1 r0 *1 0,0
R_53_t1 \$53__t1 \$53 17.162141452
* device instance _53_t2 r0 *1 0,0
R_53_t2 \$53__t2 \$53 13.6875065396
* device instance _53_t3 r0 *1 0,0
R_53_t3 \$53__t3 \$53 9.52844849363
* device instance _53_t4 r0 *1 0,0
R_53_t4 \$53__t4 \$53 16.7641747213
* device instance _53 r0 *1 0,0
C_53 \$53 vsubs 7.92193e-16
* device instance _54_t0 r0 *1 0,0
R_54_t0 \$54__t0 \$54 14.0706287935
* device instance _54_t1 r0 *1 0,0
R_54_t1 \$54__t1 \$54 17.162141452
* device instance _54_t2 r0 *1 0,0
R_54_t2 \$54__t2 \$54 13.6875065396
* device instance _54_t3 r0 *1 0,0
R_54_t3 \$54__t3 \$54 9.52844849363
* device instance _54_t4 r0 *1 0,0
R_54_t4 \$54__t4 \$54 16.7641747213
* device instance _54 r0 *1 0,0
C_54 \$54 vsubs 7.92193e-16
* device instance _55_t0 r0 *1 0,0
R_55_t0 \$55__t0 \$55 14.0706287935
* device instance _55_t1 r0 *1 0,0
R_55_t1 \$55__t1 \$55 17.162141452
* device instance _55_t2 r0 *1 0,0
R_55_t2 \$55__t2 \$55 13.6875065396
* device instance _55_t3 r0 *1 0,0
R_55_t3 \$55__t3 \$55 9.52844849363
* device instance _55_t4 r0 *1 0,0
R_55_t4 \$55__t4 \$55 16.7641747213
* device instance _55 r0 *1 0,0
C_55 \$55 vsubs 7.92193e-16
* device instance _56_t0 r0 *1 0,0
R_56_t0 \$56__t0 \$56 14.0706287935
* device instance _56_t1 r0 *1 0,0
R_56_t1 \$56__t1 \$56 17.162141452
* device instance _56_t2 r0 *1 0,0
R_56_t2 \$56__t2 \$56 13.6875065396
* device instance _56_t3 r0 *1 0,0
R_56_t3 \$56__t3 \$56 9.52844849363
* device instance _56_t4 r0 *1 0,0
R_56_t4 \$56__t4 \$56 16.7641747213
* device instance _56 r0 *1 0,0
C_56 \$56 vsubs 7.92193e-16
* device instance _57_t0 r0 *1 0,0
R_57_t0 \$57__t0 \$57 14.0706287935
* device instance _57_t1 r0 *1 0,0
R_57_t1 \$57__t1 \$57 17.162141452
* device instance _57_t2 r0 *1 0,0
R_57_t2 \$57__t2 \$57 13.6875065396
* device instance _57_t3 r0 *1 0,0
R_57_t3 \$57__t3 \$57 9.52844849363
* device instance _57_t4 r0 *1 0,0
R_57_t4 \$57__t4 \$57 16.7641747213
* device instance _57 r0 *1 0,0
C_57 \$57 vsubs 7.92193e-16
* device instance _58_t0 r0 *1 0,0
R_58_t0 \$58__t0 \$58 14.0706287935
* device instance _58_t1 r0 *1 0,0
R_58_t1 \$58__t1 \$58 17.162141452
* device instance _58_t2 r0 *1 0,0
R_58_t2 \$58__t2 \$58 13.6875065396
* device instance _58_t3 r0 *1 0,0
R_58_t3 \$58__t3 \$58 9.52844849363
* device instance _58_t4 r0 *1 0,0
R_58_t4 \$58__t4 \$58 16.7641747213
* device instance _58 r0 *1 0,0
C_58 \$58 vsubs 7.92193e-16
* device instance _59_t0 r0 *1 0,0
R_59_t0 \$59__t0 \$59 14.0706287935
* device instance _59_t1 r0 *1 0,0
R_59_t1 \$59__t1 \$59 17.162141452
* device instance _59_t2 r0 *1 0,0
R_59_t2 \$59__t2 \$59 13.6875065396
* device instance _59_t3 r0 *1 0,0
R_59_t3 \$59__t3 \$59 9.52844849363
* device instance _59_t4 r0 *1 0,0
R_59_t4 \$59__t4 \$59 16.7641747213
* device instance _59 r0 *1 0,0
C_59 \$59 vsubs 7.92193e-16
* device instance _6_t0 r0 *1 0,0
R_6_t0 \$6__t0 \$6 14.0706287935
* device instance _6_t1 r0 *1 0,0
R_6_t1 \$6__t1 \$6 17.162141452
* device instance _6_t2 r0 *1 0,0
R_6_t2 \$6__t2 \$6 13.6875065396
* device instance _6_t3 r0 *1 0,0
R_6_t3 \$6__t3 \$6 9.52844849363
* device instance _6_t4 r0 *1 0,0
R_6_t4 \$6__t4 \$6 16.7641747213
* device instance _6 r0 *1 0,0
C_6 \$6 vsubs 7.92193e-16
* device instance _60_t0 r0 *1 0,0
R_60_t0 \$60__t0 \$60 14.0706287935
* device instance _60_t1 r0 *1 0,0
R_60_t1 \$60__t1 \$60 17.162141452
* device instance _60_t2 r0 *1 0,0
R_60_t2 \$60__t2 \$60 13.6875065396
* device instance _60_t3 r0 *1 0,0
R_60_t3 \$60__t3 \$60 9.52844849363
* device instance _60_t4 r0 *1 0,0
R_60_t4 \$60__t4 \$60 16.7641747213
* device instance _60 r0 *1 0,0
C_60 \$60 vsubs 7.92193e-16
* device instance _61_t0 r0 *1 0,0
R_61_t0 \$61__t0 \$61 14.0706287935
* device instance _61_t1 r0 *1 0,0
R_61_t1 \$61__t1 \$61 17.162141452
* device instance _61_t2 r0 *1 0,0
R_61_t2 \$61__t2 \$61 13.6875065396
* device instance _61_t3 r0 *1 0,0
R_61_t3 \$61__t3 \$61 9.52844849363
* device instance _61_t4 r0 *1 0,0
R_61_t4 \$61__t4 \$61 16.7641747213
* device instance _61 r0 *1 0,0
C_61 \$61 vsubs 7.92193e-16
* device instance _62_t0 r0 *1 0,0
R_62_t0 \$62__t0 \$62 14.0706287935
* device instance _62_t1 r0 *1 0,0
R_62_t1 \$62__t1 \$62 17.162141452
* device instance _62_t2 r0 *1 0,0
R_62_t2 \$62__t2 \$62 13.6875065396
* device instance _62_t3 r0 *1 0,0
R_62_t3 \$62__t3 \$62 9.52844849363
* device instance _62_t4 r0 *1 0,0
R_62_t4 \$62__t4 \$62 16.7641747213
* device instance _62 r0 *1 0,0
C_62 \$62 vsubs 7.92193e-16
* device instance _63_t0 r0 *1 0,0
R_63_t0 \$63__t0 \$63 14.0706287935
* device instance _63_t1 r0 *1 0,0
R_63_t1 \$63__t1 \$63 17.162141452
* device instance _63_t2 r0 *1 0,0
R_63_t2 \$63__t2 \$63 13.6875065396
* device instance _63_t3 r0 *1 0,0
R_63_t3 \$63__t3 \$63 9.52844849363
* device instance _63_t4 r0 *1 0,0
R_63_t4 \$63__t4 \$63 16.7641747213
* device instance _63 r0 *1 0,0
C_63 \$63 vsubs 7.92193e-16
* device instance _64_t0 r0 *1 0,0
R_64_t0 \$64__t0 \$64 14.0706287935
* device instance _64_t1 r0 *1 0,0
R_64_t1 \$64__t1 \$64 17.162141452
* device instance _64_t2 r0 *1 0,0
R_64_t2 \$64__t2 \$64 13.6875065396
* device instance _64_t3 r0 *1 0,0
R_64_t3 \$64__t3 \$64 9.52844849363
* device instance _64_t4 r0 *1 0,0
R_64_t4 \$64__t4 \$64 16.7641747213
* device instance _64 r0 *1 0,0
C_64 \$64 vsubs 7.92193e-16
* device instance _65_t0 r0 *1 0,0
R_65_t0 \$65__t0 \$65 14.0706287935
* device instance _65_t1 r0 *1 0,0
R_65_t1 \$65__t1 \$65 17.162141452
* device instance _65_t2 r0 *1 0,0
R_65_t2 \$65__t2 \$65 13.6875065396
* device instance _65_t3 r0 *1 0,0
R_65_t3 \$65__t3 \$65 9.52844849363
* device instance _65_t4 r0 *1 0,0
R_65_t4 \$65__t4 \$65 16.7641747213
* device instance _65 r0 *1 0,0
C_65 \$65 vsubs 7.92193e-16
* device instance _66_t0 r0 *1 0,0
R_66_t0 \$66__t0 \$66 14.0706287935
* device instance _66_t1 r0 *1 0,0
R_66_t1 \$66__t1 \$66 17.162141452
* device instance _66_t2 r0 *1 0,0
R_66_t2 \$66__t2 \$66 13.6875065396
* device instance _66_t3 r0 *1 0,0
R_66_t3 \$66__t3 \$66 9.52844849363
* device instance _66_t4 r0 *1 0,0
R_66_t4 \$66__t4 \$66 16.7641747213
* device instance _66 r0 *1 0,0
C_66 \$66 vsubs 7.92193e-16
* device instance _67_t0 r0 *1 0,0
R_67_t0 \$67__t0 \$67 14.0706287935
* device instance _67_t1 r0 *1 0,0
R_67_t1 \$67__t1 \$67 17.162141452
* device instance _67_t2 r0 *1 0,0
R_67_t2 \$67__t2 \$67 13.6875065396
* device instance _67_t3 r0 *1 0,0
R_67_t3 \$67__t3 \$67 9.52844849363
* device instance _67_t4 r0 *1 0,0
R_67_t4 \$67__t4 \$67 16.7641747213
* device instance _67 r0 *1 0,0
C_67 \$67 vsubs 7.92193e-16
* device instance _69_t0 r0 *1 0,0
R_69_t0 \$69__t0 \$69 13.6875065396
* device instance _69_t1 r0 *1 0,0
R_69_t1 \$69__t1 \$69 14.0706287935
* device instance _69_t2 r0 *1 0,0
R_69_t2 \$69__t2 \$69 17.162141452
* device instance _69_t3 r0 *1 0,0
R_69_t3 \$69__t3 \$69 9.52844849363
* device instance _69_t4 r0 *1 0,0
R_69_t4 \$69__t4 \$69 16.7641747213
* device instance _69 r0 *1 0,0
C_69 \$69 vsubs 7.83841e-16
* device instance _7_t0 r0 *1 0,0
R_7_t0 \$7__t0 \$7 14.0706287935
* device instance _7_t1 r0 *1 0,0
R_7_t1 \$7__t1 \$7 17.162141452
* device instance _7_t2 r0 *1 0,0
R_7_t2 \$7__t2 \$7 13.6875065396
* device instance _7_t3 r0 *1 0,0
R_7_t3 \$7__t3 \$7 9.52844849363
* device instance _7_t4 r0 *1 0,0
R_7_t4 \$7__t4 \$7 16.7641747213
* device instance _7 r0 *1 0,0
C_7 \$7 vsubs 7.92193e-16
* device instance _72_t0 r0 *1 0,0
R_72_t0 \$72__t0 \$72 17.162141452
* device instance _72_t1 r0 *1 0,0
R_72_t1 \$72__t1 \$72 14.0706287935
* device instance _72_t2 r0 *1 0,0
R_72_t2 \$72__t2 \$72 13.6875065396
* device instance _72_t3 r0 *1 0,0
R_72_t3 \$72__t3 \$72 16.7641747213
* device instance _72_t4 r0 *1 0,0
R_72_t4 \$72__t4 \$72 9.52844849363
* device instance _72 r0 *1 0,0
C_72 \$72 vsubs 7.83841e-16
* device instance _75_t0 r0 *1 0,0
R_75_t0 \$75__t0 \$75 17.162141452
* device instance _75_t1 r0 *1 0,0
R_75_t1 \$75__t1 \$75 14.0706287935
* device instance _75_t2 r0 *1 0,0
R_75_t2 \$75__t2 \$75 13.6875065396
* device instance _75_t3 r0 *1 0,0
R_75_t3 \$75__t3 \$75 16.7641747213
* device instance _75_t4 r0 *1 0,0
R_75_t4 \$75__t4 \$75 9.52844849363
* device instance _75 r0 *1 0,0
C_75 \$75 vsubs 7.83841e-16
* device instance _78_t0 r0 *1 0,0
R_78_t0 \$78__t0 \$78 17.162141452
* device instance _78_t1 r0 *1 0,0
R_78_t1 \$78__t1 \$78 14.0706287935
* device instance _78_t2 r0 *1 0,0
R_78_t2 \$78__t2 \$78 13.6875065396
* device instance _78_t3 r0 *1 0,0
R_78_t3 \$78__t3 \$78 16.7641747213
* device instance _78_t4 r0 *1 0,0
R_78_t4 \$78__t4 \$78 9.52844849363
* device instance _78 r0 *1 0,0
C_78 \$78 vsubs 7.83841e-16
* device instance _8_t0 r0 *1 0,0
R_8_t0 \$8__t0 \$8 14.0706287935
* device instance _8_t1 r0 *1 0,0
R_8_t1 \$8__t1 \$8 17.162141452
* device instance _8_t2 r0 *1 0,0
R_8_t2 \$8__t2 \$8 13.6875065396
* device instance _8_t3 r0 *1 0,0
R_8_t3 \$8__t3 \$8 9.52844849363
* device instance _8_t4 r0 *1 0,0
R_8_t4 \$8__t4 \$8 16.7641747213
* device instance _8 r0 *1 0,0
C_8 \$8 vsubs 7.92193e-16
* device instance _81_t0 r0 *1 0,0
R_81_t0 \$81__t0 \$81 17.162141452
* device instance _81_t1 r0 *1 0,0
R_81_t1 \$81__t1 \$81 14.0706287935
* device instance _81_t2 r0 *1 0,0
R_81_t2 \$81__t2 \$81 13.6875065396
* device instance _81_t3 r0 *1 0,0
R_81_t3 \$81__t3 \$81 16.7641747213
* device instance _81_t4 r0 *1 0,0
R_81_t4 \$81__t4 \$81 9.52844849363
* device instance _81 r0 *1 0,0
C_81 \$81 vsubs 7.83841e-16
* device instance _84_t0 r0 *1 0,0
R_84_t0 \$84__t0 \$84 17.162141452
* device instance _84_t1 r0 *1 0,0
R_84_t1 \$84__t1 \$84 14.0706287935
* device instance _84_t2 r0 *1 0,0
R_84_t2 \$84__t2 \$84 13.6875065396
* device instance _84_t3 r0 *1 0,0
R_84_t3 \$84__t3 \$84 16.7641747213
* device instance _84_t4 r0 *1 0,0
R_84_t4 \$84__t4 \$84 9.52844849363
* device instance _84 r0 *1 0,0
C_84 \$84 vsubs 7.83841e-16
* device instance _87_t0 r0 *1 0,0
R_87_t0 \$87__t0 \$87 17.162141452
* device instance _87_t1 r0 *1 0,0
R_87_t1 \$87__t1 \$87 14.0706287935
* device instance _87_t2 r0 *1 0,0
R_87_t2 \$87__t2 \$87 13.6875065396
* device instance _87_t3 r0 *1 0,0
R_87_t3 \$87__t3 \$87 16.7641747213
* device instance _87_t4 r0 *1 0,0
R_87_t4 \$87__t4 \$87 9.52844849363
* device instance _87 r0 *1 0,0
C_87 \$87 vsubs 7.83841e-16
* device instance _9_t0 r0 *1 0,0
R_9_t0 \$9__t0 \$9 14.0706287935
* device instance _9_t1 r0 *1 0,0
R_9_t1 \$9__t1 \$9 17.162141452
* device instance _9_t2 r0 *1 0,0
R_9_t2 \$9__t2 \$9 13.6875065396
* device instance _9_t3 r0 *1 0,0
R_9_t3 \$9__t3 \$9 9.52844849363
* device instance _9_t4 r0 *1 0,0
R_9_t4 \$9__t4 \$9 16.7641747213
* device instance _9 r0 *1 0,0
C_9 \$9 vsubs 7.92193e-16
* device instance _90_t0 r0 *1 0,0
R_90_t0 \$90__t0 \$90 17.162141452
* device instance _90_t1 r0 *1 0,0
R_90_t1 \$90__t1 \$90 14.0706287935
* device instance _90_t2 r0 *1 0,0
R_90_t2 \$90__t2 \$90 13.6875065396
* device instance _90_t3 r0 *1 0,0
R_90_t3 \$90__t3 \$90 16.7641747213
* device instance _90_t4 r0 *1 0,0
R_90_t4 \$90__t4 \$90 9.52844849363
* device instance _90 r0 *1 0,0
C_90 \$90 vsubs 7.83841e-16
* device instance _93_t0 r0 *1 0,0
R_93_t0 \$93__t0 \$93 17.162141452
* device instance _93_t1 r0 *1 0,0
R_93_t1 \$93__t1 \$93 14.0706287935
* device instance _93_t2 r0 *1 0,0
R_93_t2 \$93__t2 \$93 13.6875065396
* device instance _93_t3 r0 *1 0,0
R_93_t3 \$93__t3 \$93 16.7641747213
* device instance _93_t4 r0 *1 0,0
R_93_t4 \$93__t4 \$93 9.52844849363
* device instance _93 r0 *1 0,0
C_93 \$93 vsubs 7.83841e-16
* device instance _96_t0 r0 *1 0,0
R_96_t0 \$96__t0 \$96 17.162141452
* device instance _96_t1 r0 *1 0,0
R_96_t1 \$96__t1 \$96 14.0706287935
* device instance _96_t2 r0 *1 0,0
R_96_t2 \$96__t2 \$96 13.6875065396
* device instance _96_t3 r0 *1 0,0
R_96_t3 \$96__t3 \$96 16.7641747213
* device instance _96_t4 r0 *1 0,0
R_96_t4 \$96__t4 \$96 9.52844849363
* device instance _96 r0 *1 0,0
C_96 \$96 vsubs 7.83841e-16
* device instance _99_t0 r0 *1 0,0
R_99_t0 \$99__t0 \$99 17.162141452
* device instance _99_t1 r0 *1 0,0
R_99_t1 \$99__t1 \$99 14.0706287935
* device instance _99_t2 r0 *1 0,0
R_99_t2 \$99__t2 \$99 13.6875065396
* device instance _99_t3 r0 *1 0,0
R_99_t3 \$99__t3 \$99 16.7641747213
* device instance _99_t4 r0 *1 0,0
R_99_t4 \$99__t4 \$99 9.52844849363
* device instance _99 r0 *1 0,0
C_99 \$99 vsubs 7.83841e-16
* device instance BL0_t0 r0 *1 0,0
RBL0_t0 BL0__t0 BL0 1.62
* device instance BL0 r0 *1 0,0
CBL0 BL0 vsubs 4.98113e-16
* device instance BL1_t0 r0 *1 0,0
RBL1_t0 BL1__t0 BL1 1.62
* device instance BL1 r0 *1 0,0
CBL1 BL1 vsubs 4.98113e-16
* device instance BL10_t0 r0 *1 0,0
RBL10_t0 BL10__t0 BL10 1.62
* device instance BL10 r0 *1 0,0
CBL10 BL10 vsubs 4.98113e-16
* device instance BL11_t0 r0 *1 0,0
RBL11_t0 BL11__t0 BL11 1.62
* device instance BL11 r0 *1 0,0
CBL11 BL11 vsubs 4.98113e-16
* device instance BL12_t0 r0 *1 0,0
RBL12_t0 BL12__t0 BL12 1.62
* device instance BL12 r0 *1 0,0
CBL12 BL12 vsubs 4.98113e-16
* device instance BL13_t0 r0 *1 0,0
RBL13_t0 BL13__t0 BL13 1.62
* device instance BL13 r0 *1 0,0
CBL13 BL13 vsubs 4.98113e-16
* device instance BL14_t0 r0 *1 0,0
RBL14_t0 BL14__t0 BL14 1.62
* device instance BL14 r0 *1 0,0
CBL14 BL14 vsubs 4.98113e-16
* device instance BL15_t0 r0 *1 0,0
RBL15_t0 BL15__t0 BL15 1.62
* device instance BL15 r0 *1 0,0
CBL15 BL15 vsubs 4.98113e-16
* device instance BL16_t0 r0 *1 0,0
RBL16_t0 BL16__t0 BL16 1.62
* device instance BL16 r0 *1 0,0
CBL16 BL16 vsubs 4.98113e-16
* device instance BL17_t0 r0 *1 0,0
RBL17_t0 BL17__t0 BL17 1.62
* device instance BL17 r0 *1 0,0
CBL17 BL17 vsubs 4.98113e-16
* device instance BL18_t0 r0 *1 0,0
RBL18_t0 BL18__t0 BL18 1.62
* device instance BL18 r0 *1 0,0
CBL18 BL18 vsubs 4.98113e-16
* device instance BL19_t0 r0 *1 0,0
RBL19_t0 BL19__t0 BL19 1.62
* device instance BL19 r0 *1 0,0
CBL19 BL19 vsubs 4.98113e-16
* device instance BL2_t0 r0 *1 0,0
RBL2_t0 BL2__t0 BL2 1.62
* device instance BL2 r0 *1 0,0
CBL2 BL2 vsubs 4.98113e-16
* device instance BL20_t0 r0 *1 0,0
RBL20_t0 BL20__t0 BL20 1.62
* device instance BL20 r0 *1 0,0
CBL20 BL20 vsubs 4.98113e-16
* device instance BL21_t0 r0 *1 0,0
RBL21_t0 BL21__t0 BL21 1.62
* device instance BL21 r0 *1 0,0
CBL21 BL21 vsubs 4.98113e-16
* device instance BL22_t0 r0 *1 0,0
RBL22_t0 BL22__t0 BL22 1.62
* device instance BL22 r0 *1 0,0
CBL22 BL22 vsubs 4.98113e-16
* device instance BL23_t0 r0 *1 0,0
RBL23_t0 BL23__t0 BL23 1.62
* device instance BL23 r0 *1 0,0
CBL23 BL23 vsubs 4.98113e-16
* device instance BL24_t0 r0 *1 0,0
RBL24_t0 BL24__t0 BL24 1.62
* device instance BL24 r0 *1 0,0
CBL24 BL24 vsubs 4.98113e-16
* device instance BL25_t0 r0 *1 0,0
RBL25_t0 BL25__t0 BL25 1.62
* device instance BL25 r0 *1 0,0
CBL25 BL25 vsubs 4.98113e-16
* device instance BL26_t0 r0 *1 0,0
RBL26_t0 BL26__t0 BL26 1.62
* device instance BL26 r0 *1 0,0
CBL26 BL26 vsubs 4.98113e-16
* device instance BL27_t0 r0 *1 0,0
RBL27_t0 BL27__t0 BL27 1.62
* device instance BL27 r0 *1 0,0
CBL27 BL27 vsubs 4.98113e-16
* device instance BL28_t0 r0 *1 0,0
RBL28_t0 BL28__t0 BL28 1.62
* device instance BL28 r0 *1 0,0
CBL28 BL28 vsubs 4.98113e-16
* device instance BL29_t0 r0 *1 0,0
RBL29_t0 BL29__t0 BL29 1.62
* device instance BL29 r0 *1 0,0
CBL29 BL29 vsubs 4.98113e-16
* device instance BL3_t0 r0 *1 0,0
RBL3_t0 BL3__t0 BL3 1.62
* device instance BL3 r0 *1 0,0
CBL3 BL3 vsubs 4.98113e-16
* device instance BL30_t0 r0 *1 0,0
RBL30_t0 BL30__t0 BL30 1.62
* device instance BL30 r0 *1 0,0
CBL30 BL30 vsubs 4.98113e-16
* device instance BL31_t0 r0 *1 0,0
RBL31_t0 BL31__t0 BL31 1.62
* device instance BL31 r0 *1 0,0
CBL31 BL31 vsubs 4.98113e-16
* device instance BL32_t0 r0 *1 0,0
RBL32_t0 BL32__t0 BL32 1.62
* device instance BL32 r0 *1 0,0
CBL32 BL32 vsubs 4.98113e-16
* device instance BL33_t0 r0 *1 0,0
RBL33_t0 BL33__t0 BL33 1.62
* device instance BL33 r0 *1 0,0
CBL33 BL33 vsubs 4.98113e-16
* device instance BL34_t0 r0 *1 0,0
RBL34_t0 BL34__t0 BL34 1.62
* device instance BL34 r0 *1 0,0
CBL34 BL34 vsubs 4.98113e-16
* device instance BL35_t0 r0 *1 0,0
RBL35_t0 BL35__t0 BL35 1.62
* device instance BL35 r0 *1 0,0
CBL35 BL35 vsubs 4.98113e-16
* device instance BL36_t0 r0 *1 0,0
RBL36_t0 BL36__t0 BL36 1.62
* device instance BL36 r0 *1 0,0
CBL36 BL36 vsubs 4.98113e-16
* device instance BL37_t0 r0 *1 0,0
RBL37_t0 BL37__t0 BL37 1.62
* device instance BL37 r0 *1 0,0
CBL37 BL37 vsubs 4.98113e-16
* device instance BL38_t0 r0 *1 0,0
RBL38_t0 BL38__t0 BL38 1.62
* device instance BL38 r0 *1 0,0
CBL38 BL38 vsubs 4.98113e-16
* device instance BL39_t0 r0 *1 0,0
RBL39_t0 BL39__t0 BL39 1.62
* device instance BL39 r0 *1 0,0
CBL39 BL39 vsubs 4.98113e-16
* device instance BL4_t0 r0 *1 0,0
RBL4_t0 BL4__t0 BL4 1.62
* device instance BL4 r0 *1 0,0
CBL4 BL4 vsubs 4.98113e-16
* device instance BL40_t0 r0 *1 0,0
RBL40_t0 BL40__t0 BL40 1.62
* device instance BL40 r0 *1 0,0
CBL40 BL40 vsubs 4.98113e-16
* device instance BL41_t0 r0 *1 0,0
RBL41_t0 BL41__t0 BL41 1.62
* device instance BL41 r0 *1 0,0
CBL41 BL41 vsubs 4.98113e-16
* device instance BL42_t0 r0 *1 0,0
RBL42_t0 BL42__t0 BL42 1.62
* device instance BL42 r0 *1 0,0
CBL42 BL42 vsubs 4.98113e-16
* device instance BL43_t0 r0 *1 0,0
RBL43_t0 BL43__t0 BL43 1.62
* device instance BL43 r0 *1 0,0
CBL43 BL43 vsubs 4.98113e-16
* device instance BL44_t0 r0 *1 0,0
RBL44_t0 BL44__t0 BL44 1.62
* device instance BL44 r0 *1 0,0
CBL44 BL44 vsubs 4.98113e-16
* device instance BL45_t0 r0 *1 0,0
RBL45_t0 BL45__t0 BL45 1.62
* device instance BL45 r0 *1 0,0
CBL45 BL45 vsubs 4.98113e-16
* device instance BL46_t0 r0 *1 0,0
RBL46_t0 BL46__t0 BL46 1.62
* device instance BL46 r0 *1 0,0
CBL46 BL46 vsubs 4.98113e-16
* device instance BL47_t0 r0 *1 0,0
RBL47_t0 BL47__t0 BL47 1.62
* device instance BL47 r0 *1 0,0
CBL47 BL47 vsubs 4.98113e-16
* device instance BL48_t0 r0 *1 0,0
RBL48_t0 BL48__t0 BL48 1.62
* device instance BL48 r0 *1 0,0
CBL48 BL48 vsubs 4.98113e-16
* device instance BL49_t0 r0 *1 0,0
RBL49_t0 BL49__t0 BL49 1.62
* device instance BL49 r0 *1 0,0
CBL49 BL49 vsubs 4.98113e-16
* device instance BL5_t0 r0 *1 0,0
RBL5_t0 BL5__t0 BL5 1.62
* device instance BL5 r0 *1 0,0
CBL5 BL5 vsubs 4.98113e-16
* device instance BL50_t0 r0 *1 0,0
RBL50_t0 BL50__t0 BL50 1.62
* device instance BL50 r0 *1 0,0
CBL50 BL50 vsubs 4.98113e-16
* device instance BL51_t0 r0 *1 0,0
RBL51_t0 BL51__t0 BL51 1.62
* device instance BL51 r0 *1 0,0
CBL51 BL51 vsubs 4.98113e-16
* device instance BL52_t0 r0 *1 0,0
RBL52_t0 BL52__t0 BL52 1.62
* device instance BL52 r0 *1 0,0
CBL52 BL52 vsubs 4.98113e-16
* device instance BL53_t0 r0 *1 0,0
RBL53_t0 BL53__t0 BL53 1.62
* device instance BL53 r0 *1 0,0
CBL53 BL53 vsubs 4.98113e-16
* device instance BL54_t0 r0 *1 0,0
RBL54_t0 BL54__t0 BL54 1.62
* device instance BL54 r0 *1 0,0
CBL54 BL54 vsubs 4.98113e-16
* device instance BL55_t0 r0 *1 0,0
RBL55_t0 BL55__t0 BL55 1.62
* device instance BL55 r0 *1 0,0
CBL55 BL55 vsubs 4.98113e-16
* device instance BL56_t0 r0 *1 0,0
RBL56_t0 BL56__t0 BL56 1.62
* device instance BL56 r0 *1 0,0
CBL56 BL56 vsubs 4.98113e-16
* device instance BL57_t0 r0 *1 0,0
RBL57_t0 BL57__t0 BL57 1.62
* device instance BL57 r0 *1 0,0
CBL57 BL57 vsubs 4.98113e-16
* device instance BL58_t0 r0 *1 0,0
RBL58_t0 BL58__t0 BL58 1.62
* device instance BL58 r0 *1 0,0
CBL58 BL58 vsubs 4.98113e-16
* device instance BL59_t0 r0 *1 0,0
RBL59_t0 BL59__t0 BL59 1.62
* device instance BL59 r0 *1 0,0
CBL59 BL59 vsubs 4.98113e-16
* device instance BL6_t0 r0 *1 0,0
RBL6_t0 BL6__t0 BL6 1.62
* device instance BL6 r0 *1 0,0
CBL6 BL6 vsubs 4.98113e-16
* device instance BL60_t0 r0 *1 0,0
RBL60_t0 BL60__t0 BL60 1.62
* device instance BL60 r0 *1 0,0
CBL60 BL60 vsubs 4.98113e-16
* device instance BL61_t0 r0 *1 0,0
RBL61_t0 BL61__t0 BL61 1.62
* device instance BL61 r0 *1 0,0
CBL61 BL61 vsubs 4.98113e-16
* device instance BL62_t0 r0 *1 0,0
RBL62_t0 BL62__t0 BL62 1.62
* device instance BL62 r0 *1 0,0
CBL62 BL62 vsubs 4.98113e-16
* device instance BL63_t0 r0 *1 0,0
RBL63_t0 BL63__t0 BL63 1.62
* device instance BL63 r0 *1 0,0
CBL63 BL63 vsubs 4.98113e-16
* device instance BL7_t0 r0 *1 0,0
RBL7_t0 BL7__t0 BL7 1.62
* device instance BL7 r0 *1 0,0
CBL7 BL7 vsubs 4.98113e-16
* device instance BL8_t0 r0 *1 0,0
RBL8_t0 BL8__t0 BL8 1.62
* device instance BL8 r0 *1 0,0
CBL8 BL8 vsubs 4.98113e-16
* device instance BL9_t0 r0 *1 0,0
RBL9_t0 BL9__t0 BL9 1.62
* device instance BL9 r0 *1 0,0
CBL9 BL9 vsubs 4.98113e-16
* device instance BLB0_t0 r0 *1 0,0
RBLB0_t0 BLB0__t0 BLB0 1.62
* device instance BLB0 r0 *1 0,0
CBLB0 BLB0 vsubs 4.98113e-16
* device instance BLB1_t0 r0 *1 0,0
RBLB1_t0 BLB1__t0 BLB1 1.62
* device instance BLB1 r0 *1 0,0
CBLB1 BLB1 vsubs 4.98113e-16
* device instance BLB10_t0 r0 *1 0,0
RBLB10_t0 BLB10__t0 BLB10 1.62
* device instance BLB10 r0 *1 0,0
CBLB10 BLB10 vsubs 4.98113e-16
* device instance BLB11_t0 r0 *1 0,0
RBLB11_t0 BLB11__t0 BLB11 1.62
* device instance BLB11 r0 *1 0,0
CBLB11 BLB11 vsubs 4.98113e-16
* device instance BLB12_t0 r0 *1 0,0
RBLB12_t0 BLB12__t0 BLB12 1.62
* device instance BLB12 r0 *1 0,0
CBLB12 BLB12 vsubs 4.98113e-16
* device instance BLB13_t0 r0 *1 0,0
RBLB13_t0 BLB13__t0 BLB13 1.62
* device instance BLB13 r0 *1 0,0
CBLB13 BLB13 vsubs 4.98113e-16
* device instance BLB14_t0 r0 *1 0,0
RBLB14_t0 BLB14__t0 BLB14 1.62
* device instance BLB14 r0 *1 0,0
CBLB14 BLB14 vsubs 4.98113e-16
* device instance BLB15_t0 r0 *1 0,0
RBLB15_t0 BLB15__t0 BLB15 1.62
* device instance BLB15 r0 *1 0,0
CBLB15 BLB15 vsubs 4.98113e-16
* device instance BLB16_t0 r0 *1 0,0
RBLB16_t0 BLB16__t0 BLB16 1.62
* device instance BLB16 r0 *1 0,0
CBLB16 BLB16 vsubs 4.98113e-16
* device instance BLB17_t0 r0 *1 0,0
RBLB17_t0 BLB17__t0 BLB17 1.62
* device instance BLB17 r0 *1 0,0
CBLB17 BLB17 vsubs 4.98113e-16
* device instance BLB18_t0 r0 *1 0,0
RBLB18_t0 BLB18__t0 BLB18 1.62
* device instance BLB18 r0 *1 0,0
CBLB18 BLB18 vsubs 4.98113e-16
* device instance BLB19_t0 r0 *1 0,0
RBLB19_t0 BLB19__t0 BLB19 1.62
* device instance BLB19 r0 *1 0,0
CBLB19 BLB19 vsubs 4.98113e-16
* device instance BLB2_t0 r0 *1 0,0
RBLB2_t0 BLB2__t0 BLB2 1.62
* device instance BLB2 r0 *1 0,0
CBLB2 BLB2 vsubs 4.98113e-16
* device instance BLB20_t0 r0 *1 0,0
RBLB20_t0 BLB20__t0 BLB20 1.62
* device instance BLB20 r0 *1 0,0
CBLB20 BLB20 vsubs 4.98113e-16
* device instance BLB21_t0 r0 *1 0,0
RBLB21_t0 BLB21__t0 BLB21 1.62
* device instance BLB21 r0 *1 0,0
CBLB21 BLB21 vsubs 4.98113e-16
* device instance BLB22_t0 r0 *1 0,0
RBLB22_t0 BLB22__t0 BLB22 1.62
* device instance BLB22 r0 *1 0,0
CBLB22 BLB22 vsubs 4.98113e-16
* device instance BLB23_t0 r0 *1 0,0
RBLB23_t0 BLB23__t0 BLB23 1.62
* device instance BLB23 r0 *1 0,0
CBLB23 BLB23 vsubs 4.98113e-16
* device instance BLB24_t0 r0 *1 0,0
RBLB24_t0 BLB24__t0 BLB24 1.62
* device instance BLB24 r0 *1 0,0
CBLB24 BLB24 vsubs 4.98113e-16
* device instance BLB25_t0 r0 *1 0,0
RBLB25_t0 BLB25__t0 BLB25 1.62
* device instance BLB25 r0 *1 0,0
CBLB25 BLB25 vsubs 4.98113e-16
* device instance BLB26_t0 r0 *1 0,0
RBLB26_t0 BLB26__t0 BLB26 1.62
* device instance BLB26 r0 *1 0,0
CBLB26 BLB26 vsubs 4.98113e-16
* device instance BLB27_t0 r0 *1 0,0
RBLB27_t0 BLB27__t0 BLB27 1.62
* device instance BLB27 r0 *1 0,0
CBLB27 BLB27 vsubs 4.98113e-16
* device instance BLB28_t0 r0 *1 0,0
RBLB28_t0 BLB28__t0 BLB28 1.62
* device instance BLB28 r0 *1 0,0
CBLB28 BLB28 vsubs 4.98113e-16
* device instance BLB29_t0 r0 *1 0,0
RBLB29_t0 BLB29__t0 BLB29 1.62
* device instance BLB29 r0 *1 0,0
CBLB29 BLB29 vsubs 4.98113e-16
* device instance BLB3_t0 r0 *1 0,0
RBLB3_t0 BLB3__t0 BLB3 1.62
* device instance BLB3 r0 *1 0,0
CBLB3 BLB3 vsubs 4.98113e-16
* device instance BLB30_t0 r0 *1 0,0
RBLB30_t0 BLB30__t0 BLB30 1.62
* device instance BLB30 r0 *1 0,0
CBLB30 BLB30 vsubs 4.98113e-16
* device instance BLB31_t0 r0 *1 0,0
RBLB31_t0 BLB31__t0 BLB31 1.62
* device instance BLB31 r0 *1 0,0
CBLB31 BLB31 vsubs 4.98113e-16
* device instance BLB32_t0 r0 *1 0,0
RBLB32_t0 BLB32__t0 BLB32 1.62
* device instance BLB32 r0 *1 0,0
CBLB32 BLB32 vsubs 4.98113e-16
* device instance BLB33_t0 r0 *1 0,0
RBLB33_t0 BLB33__t0 BLB33 1.62
* device instance BLB33 r0 *1 0,0
CBLB33 BLB33 vsubs 4.98113e-16
* device instance BLB34_t0 r0 *1 0,0
RBLB34_t0 BLB34__t0 BLB34 1.62
* device instance BLB34 r0 *1 0,0
CBLB34 BLB34 vsubs 4.98113e-16
* device instance BLB35_t0 r0 *1 0,0
RBLB35_t0 BLB35__t0 BLB35 1.62
* device instance BLB35 r0 *1 0,0
CBLB35 BLB35 vsubs 4.98113e-16
* device instance BLB36_t0 r0 *1 0,0
RBLB36_t0 BLB36__t0 BLB36 1.62
* device instance BLB36 r0 *1 0,0
CBLB36 BLB36 vsubs 4.98113e-16
* device instance BLB37_t0 r0 *1 0,0
RBLB37_t0 BLB37__t0 BLB37 1.62
* device instance BLB37 r0 *1 0,0
CBLB37 BLB37 vsubs 4.98113e-16
* device instance BLB38_t0 r0 *1 0,0
RBLB38_t0 BLB38__t0 BLB38 1.62
* device instance BLB38 r0 *1 0,0
CBLB38 BLB38 vsubs 4.98113e-16
* device instance BLB39_t0 r0 *1 0,0
RBLB39_t0 BLB39__t0 BLB39 1.62
* device instance BLB39 r0 *1 0,0
CBLB39 BLB39 vsubs 4.98113e-16
* device instance BLB4_t0 r0 *1 0,0
RBLB4_t0 BLB4__t0 BLB4 1.62
* device instance BLB4 r0 *1 0,0
CBLB4 BLB4 vsubs 4.98113e-16
* device instance BLB40_t0 r0 *1 0,0
RBLB40_t0 BLB40__t0 BLB40 1.62
* device instance BLB40 r0 *1 0,0
CBLB40 BLB40 vsubs 4.98113e-16
* device instance BLB41_t0 r0 *1 0,0
RBLB41_t0 BLB41__t0 BLB41 1.62
* device instance BLB41 r0 *1 0,0
CBLB41 BLB41 vsubs 4.98113e-16
* device instance BLB42_t0 r0 *1 0,0
RBLB42_t0 BLB42__t0 BLB42 1.62
* device instance BLB42 r0 *1 0,0
CBLB42 BLB42 vsubs 4.98113e-16
* device instance BLB43_t0 r0 *1 0,0
RBLB43_t0 BLB43__t0 BLB43 1.62
* device instance BLB43 r0 *1 0,0
CBLB43 BLB43 vsubs 4.98113e-16
* device instance BLB44_t0 r0 *1 0,0
RBLB44_t0 BLB44__t0 BLB44 1.62
* device instance BLB44 r0 *1 0,0
CBLB44 BLB44 vsubs 4.98113e-16
* device instance BLB45_t0 r0 *1 0,0
RBLB45_t0 BLB45__t0 BLB45 1.62
* device instance BLB45 r0 *1 0,0
CBLB45 BLB45 vsubs 4.98113e-16
* device instance BLB46_t0 r0 *1 0,0
RBLB46_t0 BLB46__t0 BLB46 1.62
* device instance BLB46 r0 *1 0,0
CBLB46 BLB46 vsubs 4.98113e-16
* device instance BLB47_t0 r0 *1 0,0
RBLB47_t0 BLB47__t0 BLB47 1.62
* device instance BLB47 r0 *1 0,0
CBLB47 BLB47 vsubs 4.98113e-16
* device instance BLB48_t0 r0 *1 0,0
RBLB48_t0 BLB48__t0 BLB48 1.62
* device instance BLB48 r0 *1 0,0
CBLB48 BLB48 vsubs 4.98113e-16
* device instance BLB49_t0 r0 *1 0,0
RBLB49_t0 BLB49__t0 BLB49 1.62
* device instance BLB49 r0 *1 0,0
CBLB49 BLB49 vsubs 4.98113e-16
* device instance BLB5_t0 r0 *1 0,0
RBLB5_t0 BLB5__t0 BLB5 1.62
* device instance BLB5 r0 *1 0,0
CBLB5 BLB5 vsubs 4.98113e-16
* device instance BLB50_t0 r0 *1 0,0
RBLB50_t0 BLB50__t0 BLB50 1.62
* device instance BLB50 r0 *1 0,0
CBLB50 BLB50 vsubs 4.98113e-16
* device instance BLB51_t0 r0 *1 0,0
RBLB51_t0 BLB51__t0 BLB51 1.62
* device instance BLB51 r0 *1 0,0
CBLB51 BLB51 vsubs 4.98113e-16
* device instance BLB52_t0 r0 *1 0,0
RBLB52_t0 BLB52__t0 BLB52 1.62
* device instance BLB52 r0 *1 0,0
CBLB52 BLB52 vsubs 4.98113e-16
* device instance BLB53_t0 r0 *1 0,0
RBLB53_t0 BLB53__t0 BLB53 1.62
* device instance BLB53 r0 *1 0,0
CBLB53 BLB53 vsubs 4.98113e-16
* device instance BLB54_t0 r0 *1 0,0
RBLB54_t0 BLB54__t0 BLB54 1.62
* device instance BLB54 r0 *1 0,0
CBLB54 BLB54 vsubs 4.98113e-16
* device instance BLB55_t0 r0 *1 0,0
RBLB55_t0 BLB55__t0 BLB55 1.62
* device instance BLB55 r0 *1 0,0
CBLB55 BLB55 vsubs 4.98113e-16
* device instance BLB56_t0 r0 *1 0,0
RBLB56_t0 BLB56__t0 BLB56 1.62
* device instance BLB56 r0 *1 0,0
CBLB56 BLB56 vsubs 4.98113e-16
* device instance BLB57_t0 r0 *1 0,0
RBLB57_t0 BLB57__t0 BLB57 1.62
* device instance BLB57 r0 *1 0,0
CBLB57 BLB57 vsubs 4.98113e-16
* device instance BLB58_t0 r0 *1 0,0
RBLB58_t0 BLB58__t0 BLB58 1.62
* device instance BLB58 r0 *1 0,0
CBLB58 BLB58 vsubs 4.98113e-16
* device instance BLB59_t0 r0 *1 0,0
RBLB59_t0 BLB59__t0 BLB59 1.62
* device instance BLB59 r0 *1 0,0
CBLB59 BLB59 vsubs 4.98113e-16
* device instance BLB6_t0 r0 *1 0,0
RBLB6_t0 BLB6__t0 BLB6 1.62
* device instance BLB6 r0 *1 0,0
CBLB6 BLB6 vsubs 4.98113e-16
* device instance BLB60_t0 r0 *1 0,0
RBLB60_t0 BLB60__t0 BLB60 1.62
* device instance BLB60 r0 *1 0,0
CBLB60 BLB60 vsubs 4.98113e-16
* device instance BLB61_t0 r0 *1 0,0
RBLB61_t0 BLB61__t0 BLB61 1.62
* device instance BLB61 r0 *1 0,0
CBLB61 BLB61 vsubs 4.98113e-16
* device instance BLB62_t0 r0 *1 0,0
RBLB62_t0 BLB62__t0 BLB62 1.62
* device instance BLB62 r0 *1 0,0
CBLB62 BLB62 vsubs 4.98113e-16
* device instance BLB63_t0 r0 *1 0,0
RBLB63_t0 BLB63__t0 BLB63 1.62
* device instance BLB63 r0 *1 0,0
CBLB63 BLB63 vsubs 4.98113e-16
* device instance BLB7_t0 r0 *1 0,0
RBLB7_t0 BLB7__t0 BLB7 1.62
* device instance BLB7 r0 *1 0,0
CBLB7 BLB7 vsubs 4.98113e-16
* device instance BLB8_t0 r0 *1 0,0
RBLB8_t0 BLB8__t0 BLB8 1.62
* device instance BLB8 r0 *1 0,0
CBLB8 BLB8 vsubs 4.98113e-16
* device instance BLB9_t0 r0 *1 0,0
RBLB9_t0 BLB9__t0 BLB9 1.62
* device instance BLB9 r0 *1 0,0
CBLB9 BLB9 vsubs 4.98113e-16
* device instance VDD_t0 r0 *1 0,0
RVDD_t0 VDD__t0 VDD 1.50261317637
* device instance VDD_t1 r0 *1 0,0
RVDD_t1 VDD__t1 VDD 1.49004524648
* device instance VDD_t2 r0 *1 0,0
RVDD_t2 VDD__t2 VDD 0.552562883399
* device instance VDD_t3 r0 *1 0,0
RVDD_t3 VDD__t3 VDD 0.505060368751
* device instance VDD_t4 r0 *1 0,0
RVDD_t4 VDD__t4 VDD 0.457557854102
* device instance VDD_t5 r0 *1 0,0
RVDD_t5 VDD__t5 VDD 0.410055339454
* device instance VDD_t6 r0 *1 0,0
RVDD_t6 VDD__t6 VDD 0.362552824806
* device instance VDD_t7 r0 *1 0,0
RVDD_t7 VDD__t7 VDD 0.315050310157
* device instance VDD_t8 r0 *1 0,0
RVDD_t8 VDD__t8 VDD 0.267547795509
* device instance VDD_t9 r0 *1 0,0
RVDD_t9 VDD__t9 VDD 0.22004528086
* device instance VDD_t10 r0 *1 0,0
RVDD_t10 VDD__t10 VDD 1.26510060313
* device instance VDD_t11 r0 *1 0,0
RVDD_t11 VDD__t11 VDD 0.125040251563
* device instance VDD_t12 r0 *1 0,0
RVDD_t12 VDD__t12 VDD 0.0775377369149
* device instance VDD_t13 r0 *1 0,0
RVDD_t13 VDD__t13 VDD 0.0300352222665
* device instance VDD_t14 r0 *1 0,0
RVDD_t14 VDD__t14 VDD 1.50261317637
* device instance VDD_t15 r0 *1 0,0
RVDD_t15 VDD__t15 VDD 1.45511066172
* device instance VDD_t16 r0 *1 0,0
RVDD_t16 VDD__t16 VDD 1.40760814707
* device instance VDD_t17 r0 *1 0,0
RVDD_t17 VDD__t17 VDD 1.36010563242
* device instance VDD_t18 r0 *1 0,0
RVDD_t18 VDD__t18 VDD 1.31260311777
* device instance VDD_t19 r0 *1 0,0
RVDD_t19 VDD__t19 VDD 0.172542766212
* device instance VDD_t20 r0 *1 0,0
RVDD_t20 VDD__t20 VDD 0.0649698070304
* device instance VDD_t21 r0 *1 0,0
RVDD_t21 VDD__t21 VDD 0.112472321679
* device instance VDD_t22 r0 *1 0,0
RVDD_t22 VDD__t22 VDD 0.159974836327
* device instance VDD_t23 r0 *1 0,0
RVDD_t23 VDD__t23 VDD 0.207477350976
* device instance VDD_t24 r0 *1 0,0
RVDD_t24 VDD__t24 VDD 0.254979865624
* device instance VDD_t25 r0 *1 0,0
RVDD_t25 VDD__t25 VDD 0.302482380273
* device instance VDD_t26 r0 *1 0,0
RVDD_t26 VDD__t26 VDD 0.349984894921
* device instance VDD_t27 r0 *1 0,0
RVDD_t27 VDD__t27 VDD 0.397487409569
* device instance VDD_t28 r0 *1 0,0
RVDD_t28 VDD__t28 VDD 0.600065398048
* device instance VDD_t29 r0 *1 0,0
RVDD_t29 VDD__t29 VDD 0.492492438866
* device instance VDD_t30 r0 *1 0,0
RVDD_t30 VDD__t30 VDD 0.539994953515
* device instance VDD_t31 r0 *1 0,0
RVDD_t31 VDD__t31 VDD 0.587497468163
* device instance VDD_t32 r0 *1 0,0
RVDD_t32 VDD__t32 VDD 0.634999982812
* device instance VDD_t33 r0 *1 0,0
RVDD_t33 VDD__t33 VDD 0.68250249746
* device instance VDD_t34 r0 *1 0,0
RVDD_t34 VDD__t34 VDD 0.730005012108
* device instance VDD_t35 r0 *1 0,0
RVDD_t35 VDD__t35 VDD 0.742572941993
* device instance VDD_t36 r0 *1 0,0
RVDD_t36 VDD__t36 VDD 0.695070427345
* device instance VDD_t37 r0 *1 0,0
RVDD_t37 VDD__t37 VDD 0.647567912696
* device instance VDD_t38 r0 *1 0,0
RVDD_t38 VDD__t38 VDD 0.444989924218
* device instance VDD_t39 r0 *1 0,0
RVDD_t39 VDD__t39 VDD 1.07509054453
* device instance VDD_t40 r0 *1 0,0
RVDD_t40 VDD__t40 VDD 0.920015070702
* device instance VDD_t41 r0 *1 0,0
RVDD_t41 VDD__t41 VDD 1.39504021719
* device instance VDD_t42 r0 *1 0,0
RVDD_t42 VDD__t42 VDD 1.34753770254
* device instance VDD_t43 r0 *1 0,0
RVDD_t43 VDD__t43 VDD 0.967517585351
* device instance VDD_t44 r0 *1 0,0
RVDD_t44 VDD__t44 VDD 1.02758802988
* device instance VDD_t45 r0 *1 0,0
RVDD_t45 VDD__t45 VDD 1.30003518789
* device instance VDD_t46 r0 *1 0,0
RVDD_t46 VDD__t46 VDD 1.44254273184
* device instance VDD_t47 r0 *1 0,0
RVDD_t47 VDD__t47 VDD 1.25253267324
* device instance VDD_t48 r0 *1 0,0
RVDD_t48 VDD__t48 VDD 0.980085515235
* device instance VDD_t49 r0 *1 0,0
RVDD_t49 VDD__t49 VDD 0.885080485938
* device instance VDD_t50 r0 *1 0,0
RVDD_t50 VDD__t50 VDD 1.20503015859
* device instance VDD_t51 r0 *1 0,0
RVDD_t51 VDD__t51 VDD 1.06252261465
* device instance VDD_t52 r0 *1 0,0
RVDD_t52 VDD__t52 VDD 1.15752764394
* device instance VDD_t53 r0 *1 0,0
RVDD_t53 VDD__t53 VDD 0.932583000587
* device instance VDD_t54 r0 *1 0,0
RVDD_t54 VDD__t54 VDD 1.1100251293
* device instance VDD_t55 r0 *1 0,0
RVDD_t55 VDD__t55 VDD 1.0150201
* device instance VDD_t56 r0 *1 0,0
RVDD_t56 VDD__t56 VDD 0.825010041405
* device instance VDD_t57 r0 *1 0,0
RVDD_t57 VDD__t57 VDD 1.17009557383
* device instance VDD_t58 r0 *1 0,0
RVDD_t58 VDD__t58 VDD 0.83757797129
* device instance VDD_t59 r0 *1 0,0
RVDD_t59 VDD__t59 VDD 0.790075456642
* device instance VDD_t60 r0 *1 0,0
RVDD_t60 VDD__t60 VDD 1.12259305918
* device instance VDD_t61 r0 *1 0,0
RVDD_t61 VDD__t61 VDD 1.21759808848
* device instance VDD_t62 r0 *1 0,0
RVDD_t62 VDD__t62 VDD 0.872512556054
* device instance VDD_t63 r0 *1 0,0
RVDD_t63 VDD__t63 VDD 0.0174672923819
* device instance VDD_t64 r0 *1 0,0
RVDD_t64 VDD__t64 VDD 0.777507526757
* device instance VDD_t65 r0 *1 0,0
RVDD_t65 VDD__t65 VDD 0.0775377369149
* device instance VDD_t66 r0 *1 0,0
RVDD_t66 VDD__t66 VDD 0.647567912696
* device instance VDD_t67 r0 *1 0,0
RVDD_t67 VDD__t67 VDD 0.600065398048
* device instance VDD_t68 r0 *1 0,0
RVDD_t68 VDD__t68 VDD 0.777507526757
* device instance VDD_t69 r0 *1 0,0
RVDD_t69 VDD__t69 VDD 0.125040251563
* device instance VDD_t70 r0 *1 0,0
RVDD_t70 VDD__t70 VDD 0.920015070702
* device instance VDD_t71 r0 *1 0,0
RVDD_t71 VDD__t71 VDD 0.552562883399
* device instance VDD_t72 r0 *1 0,0
RVDD_t72 VDD__t72 VDD 0.172542766212
* device instance VDD_t73 r0 *1 0,0
RVDD_t73 VDD__t73 VDD 0.872512556054
* device instance VDD_t74 r0 *1 0,0
RVDD_t74 VDD__t74 VDD 0.457557854102
* device instance VDD_t75 r0 *1 0,0
RVDD_t75 VDD__t75 VDD 0.22004528086
* device instance VDD_t76 r0 *1 0,0
RVDD_t76 VDD__t76 VDD 0.410055339454
* device instance VDD_t77 r0 *1 0,0
RVDD_t77 VDD__t77 VDD 0.695070427345
* device instance VDD_t78 r0 *1 0,0
RVDD_t78 VDD__t78 VDD 0.362552824806
* device instance VDD_t79 r0 *1 0,0
RVDD_t79 VDD__t79 VDD 0.267547795509
* device instance VDD_t80 r0 *1 0,0
RVDD_t80 VDD__t80 VDD 0.825010041405
* device instance VDD_t81 r0 *1 0,0
RVDD_t81 VDD__t81 VDD 0.315050310157
* device instance VDD_t82 r0 *1 0,0
RVDD_t82 VDD__t82 VDD 0.505060368751
* device instance VDD_t83 r0 *1 0,0
RVDD_t83 VDD__t83 VDD 1.25253267324
* device instance VDD_t84 r0 *1 0,0
RVDD_t84 VDD__t84 VDD 1.30003518789
* device instance VDD_t85 r0 *1 0,0
RVDD_t85 VDD__t85 VDD 1.34753770254
* device instance VDD_t86 r0 *1 0,0
RVDD_t86 VDD__t86 VDD 1.20503015859
* device instance VDD_t87 r0 *1 0,0
RVDD_t87 VDD__t87 VDD 1.39504021719
* device instance VDD_t88 r0 *1 0,0
RVDD_t88 VDD__t88 VDD 1.44254273184
* device instance VDD_t89 r0 *1 0,0
RVDD_t89 VDD__t89 VDD 1.15752764394
* device instance VDD_t90 r0 *1 0,0
RVDD_t90 VDD__t90 VDD 1.49004524648
* device instance VDD_t91 r0 *1 0,0
RVDD_t91 VDD__t91 VDD 0.0174672923819
* device instance VDD_t92 r0 *1 0,0
RVDD_t92 VDD__t92 VDD 0.0649698070304
* device instance VDD_t93 r0 *1 0,0
RVDD_t93 VDD__t93 VDD 1.1100251293
* device instance VDD_t94 r0 *1 0,0
RVDD_t94 VDD__t94 VDD 0.112472321679
* device instance VDD_t95 r0 *1 0,0
RVDD_t95 VDD__t95 VDD 0.159974836327
* device instance VDD_t96 r0 *1 0,0
RVDD_t96 VDD__t96 VDD 0.0300352222665
* device instance VDD_t97 r0 *1 0,0
RVDD_t97 VDD__t97 VDD 0.254979865624
* device instance VDD_t98 r0 *1 0,0
RVDD_t98 VDD__t98 VDD 1.06252261465
* device instance VDD_t99 r0 *1 0,0
RVDD_t99 VDD__t99 VDD 0.302482380273
* device instance VDD_t100 r0 *1 0,0
RVDD_t100 VDD__t100 VDD 0.349984894921
* device instance VDD_t101 r0 *1 0,0
RVDD_t101 VDD__t101 VDD 0.397487409569
* device instance VDD_t102 r0 *1 0,0
RVDD_t102 VDD__t102 VDD 0.444989924218
* device instance VDD_t103 r0 *1 0,0
RVDD_t103 VDD__t103 VDD 1.0150201
* device instance VDD_t104 r0 *1 0,0
RVDD_t104 VDD__t104 VDD 0.492492438866
* device instance VDD_t105 r0 *1 0,0
RVDD_t105 VDD__t105 VDD 0.539994953515
* device instance VDD_t106 r0 *1 0,0
RVDD_t106 VDD__t106 VDD 0.587497468163
* device instance VDD_t107 r0 *1 0,0
RVDD_t107 VDD__t107 VDD 0.634999982812
* device instance VDD_t108 r0 *1 0,0
RVDD_t108 VDD__t108 VDD 0.967517585351
* device instance VDD_t109 r0 *1 0,0
RVDD_t109 VDD__t109 VDD 0.68250249746
* device instance VDD_t110 r0 *1 0,0
RVDD_t110 VDD__t110 VDD 0.730005012108
* device instance VDD_t111 r0 *1 0,0
RVDD_t111 VDD__t111 VDD 0.207477350976
* device instance VDD_t112 r0 *1 0,0
RVDD_t112 VDD__t112 VDD 0.790075456642
* device instance VDD_t113 r0 *1 0,0
RVDD_t113 VDD__t113 VDD 0.83757797129
* device instance VDD_t114 r0 *1 0,0
RVDD_t114 VDD__t114 VDD 0.885080485938
* device instance VDD_t115 r0 *1 0,0
RVDD_t115 VDD__t115 VDD 0.932583000587
* device instance VDD_t116 r0 *1 0,0
RVDD_t116 VDD__t116 VDD 0.980085515235
* device instance VDD_t117 r0 *1 0,0
RVDD_t117 VDD__t117 VDD 1.02758802988
* device instance VDD_t118 r0 *1 0,0
RVDD_t118 VDD__t118 VDD 1.07509054453
* device instance VDD_t119 r0 *1 0,0
RVDD_t119 VDD__t119 VDD 1.12259305918
* device instance VDD_t120 r0 *1 0,0
RVDD_t120 VDD__t120 VDD 1.17009557383
* device instance VDD_t121 r0 *1 0,0
RVDD_t121 VDD__t121 VDD 1.21759808848
* device instance VDD_t122 r0 *1 0,0
RVDD_t122 VDD__t122 VDD 1.26510060313
* device instance VDD_t123 r0 *1 0,0
RVDD_t123 VDD__t123 VDD 1.31260311777
* device instance VDD_t124 r0 *1 0,0
RVDD_t124 VDD__t124 VDD 1.36010563242
* device instance VDD_t125 r0 *1 0,0
RVDD_t125 VDD__t125 VDD 1.40760814707
* device instance VDD_t126 r0 *1 0,0
RVDD_t126 VDD__t126 VDD 1.45511066172
* device instance VDD_t127 r0 *1 0,0
RVDD_t127 VDD__t127 VDD 0.742572941993
* device instance VDD_t128 r0 *1 0,0
RVDD_t128 VDD__t128 VDD 1.49004524648
* device instance VDD_t129 r0 *1 0,0
RVDD_t129 VDD__t129 VDD 1.50261317637
* device instance VDD_t130 r0 *1 0,0
RVDD_t130 VDD__t130 VDD 0.0775377369149
* device instance VDD_t131 r0 *1 0,0
RVDD_t131 VDD__t131 VDD 0.647567912696
* device instance VDD_t132 r0 *1 0,0
RVDD_t132 VDD__t132 VDD 0.600065398048
* device instance VDD_t133 r0 *1 0,0
RVDD_t133 VDD__t133 VDD 0.777507526757
* device instance VDD_t134 r0 *1 0,0
RVDD_t134 VDD__t134 VDD 0.125040251563
* device instance VDD_t135 r0 *1 0,0
RVDD_t135 VDD__t135 VDD 0.920015070702
* device instance VDD_t136 r0 *1 0,0
RVDD_t136 VDD__t136 VDD 0.552562883399
* device instance VDD_t137 r0 *1 0,0
RVDD_t137 VDD__t137 VDD 0.172542766212
* device instance VDD_t138 r0 *1 0,0
RVDD_t138 VDD__t138 VDD 0.872512556054
* device instance VDD_t139 r0 *1 0,0
RVDD_t139 VDD__t139 VDD 0.457557854102
* device instance VDD_t140 r0 *1 0,0
RVDD_t140 VDD__t140 VDD 0.22004528086
* device instance VDD_t141 r0 *1 0,0
RVDD_t141 VDD__t141 VDD 0.410055339454
* device instance VDD_t142 r0 *1 0,0
RVDD_t142 VDD__t142 VDD 0.695070427345
* device instance VDD_t143 r0 *1 0,0
RVDD_t143 VDD__t143 VDD 0.362552824806
* device instance VDD_t144 r0 *1 0,0
RVDD_t144 VDD__t144 VDD 0.267547795509
* device instance VDD_t145 r0 *1 0,0
RVDD_t145 VDD__t145 VDD 0.825010041405
* device instance VDD_t146 r0 *1 0,0
RVDD_t146 VDD__t146 VDD 0.315050310157
* device instance VDD_t147 r0 *1 0,0
RVDD_t147 VDD__t147 VDD 0.505060368751
* device instance VDD_t148 r0 *1 0,0
RVDD_t148 VDD__t148 VDD 1.25253267324
* device instance VDD_t149 r0 *1 0,0
RVDD_t149 VDD__t149 VDD 1.30003518789
* device instance VDD_t150 r0 *1 0,0
RVDD_t150 VDD__t150 VDD 1.34753770254
* device instance VDD_t151 r0 *1 0,0
RVDD_t151 VDD__t151 VDD 1.20503015859
* device instance VDD_t152 r0 *1 0,0
RVDD_t152 VDD__t152 VDD 1.39504021719
* device instance VDD_t153 r0 *1 0,0
RVDD_t153 VDD__t153 VDD 1.44254273184
* device instance VDD_t154 r0 *1 0,0
RVDD_t154 VDD__t154 VDD 1.15752764394
* device instance VDD_t155 r0 *1 0,0
RVDD_t155 VDD__t155 VDD 1.49004524648
* device instance VDD_t156 r0 *1 0,0
RVDD_t156 VDD__t156 VDD 0.0174672923819
* device instance VDD_t157 r0 *1 0,0
RVDD_t157 VDD__t157 VDD 0.0649698070304
* device instance VDD_t158 r0 *1 0,0
RVDD_t158 VDD__t158 VDD 1.1100251293
* device instance VDD_t159 r0 *1 0,0
RVDD_t159 VDD__t159 VDD 0.112472321679
* device instance VDD_t160 r0 *1 0,0
RVDD_t160 VDD__t160 VDD 0.159974836327
* device instance VDD_t161 r0 *1 0,0
RVDD_t161 VDD__t161 VDD 0.0300352222665
* device instance VDD_t162 r0 *1 0,0
RVDD_t162 VDD__t162 VDD 0.254979865624
* device instance VDD_t163 r0 *1 0,0
RVDD_t163 VDD__t163 VDD 1.06252261465
* device instance VDD_t164 r0 *1 0,0
RVDD_t164 VDD__t164 VDD 0.302482380273
* device instance VDD_t165 r0 *1 0,0
RVDD_t165 VDD__t165 VDD 0.349984894921
* device instance VDD_t166 r0 *1 0,0
RVDD_t166 VDD__t166 VDD 0.397487409569
* device instance VDD_t167 r0 *1 0,0
RVDD_t167 VDD__t167 VDD 0.444989924218
* device instance VDD_t168 r0 *1 0,0
RVDD_t168 VDD__t168 VDD 1.0150201
* device instance VDD_t169 r0 *1 0,0
RVDD_t169 VDD__t169 VDD 0.492492438866
* device instance VDD_t170 r0 *1 0,0
RVDD_t170 VDD__t170 VDD 0.539994953515
* device instance VDD_t171 r0 *1 0,0
RVDD_t171 VDD__t171 VDD 0.587497468163
* device instance VDD_t172 r0 *1 0,0
RVDD_t172 VDD__t172 VDD 0.634999982812
* device instance VDD_t173 r0 *1 0,0
RVDD_t173 VDD__t173 VDD 0.967517585351
* device instance VDD_t174 r0 *1 0,0
RVDD_t174 VDD__t174 VDD 0.68250249746
* device instance VDD_t175 r0 *1 0,0
RVDD_t175 VDD__t175 VDD 0.730005012108
* device instance VDD_t176 r0 *1 0,0
RVDD_t176 VDD__t176 VDD 0.207477350976
* device instance VDD_t177 r0 *1 0,0
RVDD_t177 VDD__t177 VDD 0.790075456642
* device instance VDD_t178 r0 *1 0,0
RVDD_t178 VDD__t178 VDD 0.83757797129
* device instance VDD_t179 r0 *1 0,0
RVDD_t179 VDD__t179 VDD 0.885080485938
* device instance VDD_t180 r0 *1 0,0
RVDD_t180 VDD__t180 VDD 0.932583000587
* device instance VDD_t181 r0 *1 0,0
RVDD_t181 VDD__t181 VDD 0.980085515235
* device instance VDD_t182 r0 *1 0,0
RVDD_t182 VDD__t182 VDD 1.02758802988
* device instance VDD_t183 r0 *1 0,0
RVDD_t183 VDD__t183 VDD 1.07509054453
* device instance VDD_t184 r0 *1 0,0
RVDD_t184 VDD__t184 VDD 1.12259305918
* device instance VDD_t185 r0 *1 0,0
RVDD_t185 VDD__t185 VDD 1.17009557383
* device instance VDD_t186 r0 *1 0,0
RVDD_t186 VDD__t186 VDD 1.21759808848
* device instance VDD_t187 r0 *1 0,0
RVDD_t187 VDD__t187 VDD 1.26510060313
* device instance VDD_t188 r0 *1 0,0
RVDD_t188 VDD__t188 VDD 1.31260311777
* device instance VDD_t189 r0 *1 0,0
RVDD_t189 VDD__t189 VDD 1.36010563242
* device instance VDD_t190 r0 *1 0,0
RVDD_t190 VDD__t190 VDD 1.40760814707
* device instance VDD_t191 r0 *1 0,0
RVDD_t191 VDD__t191 VDD 1.45511066172
* device instance VDD_t192 r0 *1 0,0
RVDD_t192 VDD__t192 VDD 0.742572941993
* device instance VDD_t193 r0 *1 0,0
RVDD_t193 VDD__t193 VDD 0.552562883399
* device instance VDD_t194 r0 *1 0,0
RVDD_t194 VDD__t194 VDD 0.505060368751
* device instance VDD_t195 r0 *1 0,0
RVDD_t195 VDD__t195 VDD 0.457557854102
* device instance VDD_t196 r0 *1 0,0
RVDD_t196 VDD__t196 VDD 0.410055339454
* device instance VDD_t197 r0 *1 0,0
RVDD_t197 VDD__t197 VDD 0.362552824806
* device instance VDD_t198 r0 *1 0,0
RVDD_t198 VDD__t198 VDD 0.315050310157
* device instance VDD_t199 r0 *1 0,0
RVDD_t199 VDD__t199 VDD 0.267547795509
* device instance VDD_t200 r0 *1 0,0
RVDD_t200 VDD__t200 VDD 0.22004528086
* device instance VDD_t201 r0 *1 0,0
RVDD_t201 VDD__t201 VDD 1.26510060313
* device instance VDD_t202 r0 *1 0,0
RVDD_t202 VDD__t202 VDD 0.125040251563
* device instance VDD_t203 r0 *1 0,0
RVDD_t203 VDD__t203 VDD 0.0775377369149
* device instance VDD_t204 r0 *1 0,0
RVDD_t204 VDD__t204 VDD 0.0300352222665
* device instance VDD_t205 r0 *1 0,0
RVDD_t205 VDD__t205 VDD 1.50261317637
* device instance VDD_t206 r0 *1 0,0
RVDD_t206 VDD__t206 VDD 1.45511066172
* device instance VDD_t207 r0 *1 0,0
RVDD_t207 VDD__t207 VDD 1.40760814707
* device instance VDD_t208 r0 *1 0,0
RVDD_t208 VDD__t208 VDD 1.36010563242
* device instance VDD_t209 r0 *1 0,0
RVDD_t209 VDD__t209 VDD 1.31260311777
* device instance VDD_t210 r0 *1 0,0
RVDD_t210 VDD__t210 VDD 0.172542766212
* device instance VDD_t211 r0 *1 0,0
RVDD_t211 VDD__t211 VDD 0.0649698070304
* device instance VDD_t212 r0 *1 0,0
RVDD_t212 VDD__t212 VDD 0.112472321679
* device instance VDD_t213 r0 *1 0,0
RVDD_t213 VDD__t213 VDD 0.159974836327
* device instance VDD_t214 r0 *1 0,0
RVDD_t214 VDD__t214 VDD 0.207477350976
* device instance VDD_t215 r0 *1 0,0
RVDD_t215 VDD__t215 VDD 0.254979865624
* device instance VDD_t216 r0 *1 0,0
RVDD_t216 VDD__t216 VDD 0.302482380273
* device instance VDD_t217 r0 *1 0,0
RVDD_t217 VDD__t217 VDD 0.349984894921
* device instance VDD_t218 r0 *1 0,0
RVDD_t218 VDD__t218 VDD 0.397487409569
* device instance VDD_t219 r0 *1 0,0
RVDD_t219 VDD__t219 VDD 0.600065398048
* device instance VDD_t220 r0 *1 0,0
RVDD_t220 VDD__t220 VDD 0.492492438866
* device instance VDD_t221 r0 *1 0,0
RVDD_t221 VDD__t221 VDD 0.539994953515
* device instance VDD_t222 r0 *1 0,0
RVDD_t222 VDD__t222 VDD 0.587497468163
* device instance VDD_t223 r0 *1 0,0
RVDD_t223 VDD__t223 VDD 0.634999982812
* device instance VDD_t224 r0 *1 0,0
RVDD_t224 VDD__t224 VDD 0.68250249746
* device instance VDD_t225 r0 *1 0,0
RVDD_t225 VDD__t225 VDD 0.730005012108
* device instance VDD_t226 r0 *1 0,0
RVDD_t226 VDD__t226 VDD 0.742572941993
* device instance VDD_t227 r0 *1 0,0
RVDD_t227 VDD__t227 VDD 0.695070427345
* device instance VDD_t228 r0 *1 0,0
RVDD_t228 VDD__t228 VDD 0.647567912696
* device instance VDD_t229 r0 *1 0,0
RVDD_t229 VDD__t229 VDD 0.444989924218
* device instance VDD_t230 r0 *1 0,0
RVDD_t230 VDD__t230 VDD 1.07509054453
* device instance VDD_t231 r0 *1 0,0
RVDD_t231 VDD__t231 VDD 0.920015070702
* device instance VDD_t232 r0 *1 0,0
RVDD_t232 VDD__t232 VDD 1.39504021719
* device instance VDD_t233 r0 *1 0,0
RVDD_t233 VDD__t233 VDD 1.34753770254
* device instance VDD_t234 r0 *1 0,0
RVDD_t234 VDD__t234 VDD 0.967517585351
* device instance VDD_t235 r0 *1 0,0
RVDD_t235 VDD__t235 VDD 1.02758802988
* device instance VDD_t236 r0 *1 0,0
RVDD_t236 VDD__t236 VDD 1.30003518789
* device instance VDD_t237 r0 *1 0,0
RVDD_t237 VDD__t237 VDD 1.44254273184
* device instance VDD_t238 r0 *1 0,0
RVDD_t238 VDD__t238 VDD 1.25253267324
* device instance VDD_t239 r0 *1 0,0
RVDD_t239 VDD__t239 VDD 0.980085515235
* device instance VDD_t240 r0 *1 0,0
RVDD_t240 VDD__t240 VDD 0.885080485938
* device instance VDD_t241 r0 *1 0,0
RVDD_t241 VDD__t241 VDD 1.20503015859
* device instance VDD_t242 r0 *1 0,0
RVDD_t242 VDD__t242 VDD 1.06252261465
* device instance VDD_t243 r0 *1 0,0
RVDD_t243 VDD__t243 VDD 1.15752764394
* device instance VDD_t244 r0 *1 0,0
RVDD_t244 VDD__t244 VDD 0.932583000587
* device instance VDD_t245 r0 *1 0,0
RVDD_t245 VDD__t245 VDD 1.1100251293
* device instance VDD_t246 r0 *1 0,0
RVDD_t246 VDD__t246 VDD 1.0150201
* device instance VDD_t247 r0 *1 0,0
RVDD_t247 VDD__t247 VDD 0.825010041405
* device instance VDD_t248 r0 *1 0,0
RVDD_t248 VDD__t248 VDD 1.17009557383
* device instance VDD_t249 r0 *1 0,0
RVDD_t249 VDD__t249 VDD 0.83757797129
* device instance VDD_t250 r0 *1 0,0
RVDD_t250 VDD__t250 VDD 0.790075456642
* device instance VDD_t251 r0 *1 0,0
RVDD_t251 VDD__t251 VDD 1.12259305918
* device instance VDD_t252 r0 *1 0,0
RVDD_t252 VDD__t252 VDD 1.21759808848
* device instance VDD_t253 r0 *1 0,0
RVDD_t253 VDD__t253 VDD 0.872512556054
* device instance VDD_t254 r0 *1 0,0
RVDD_t254 VDD__t254 VDD 0.0174672923819
* device instance VDD_t255 r0 *1 0,0
RVDD_t255 VDD__t255 VDD 0.777507526757
* device instance VDD r0 *1 0,0
CVDD VDD vsubs 6.7077006e-14
* device instance VSS_t0 r0 *1 0,0
RVSS_t0 VSS__t0 VSS 0.990408237144
* device instance VSS_t1 r0 *1 0,0
RVSS_t1 VSS__t1 VSS 0.998761930468
* device instance VSS_t2 r0 *1 0,0
RVSS_t2 VSS__t2 VSS 0.579944563086
* device instance VSS_t3 r0 *1 0,0
RVSS_t3 VSS__t3 VSS 0.335705234472
* device instance VSS_t4 r0 *1 0,0
RVSS_t4 VSS__t4 VSS 0.27255698274
* device instance VSS_t5 r0 *1 0,0
RVSS_t5 VSS__t5 VSS 0.872465414622
* device instance VSS_t6 r0 *1 0,0
RVSS_t6 VSS__t6 VSS 0.809317156869
* device instance VSS_t7 r0 *1 0,0
RVSS_t7 VSS__t7 VSS 0.611518691518
* device instance VSS_t8 r0 *1 0,0
RVSS_t8 VSS__t8 VSS 0.840891285729
* device instance VSS_t9 r0 *1 0,0
RVSS_t9 VSS__t9 VSS 0.304131108247
* device instance VSS_t10 r0 *1 0,0
RVSS_t10 VSS__t10 VSS 0.777743028047
* device instance VSS_t11 r0 *1 0,0
RVSS_t11 VSS__t11 VSS 0.358925668456
* device instance VSS_t12 r0 *1 0,0
RVSS_t12 VSS__t12 VSS 0.146260497198
* device instance VSS_t13 r0 *1 0,0
RVSS_t13 VSS__t13 VSS 0.295777415769
* device instance VSS_t14 r0 *1 0,0
RVSS_t14 VSS__t14 VSS 0.390499795523
* device instance VSS_t15 r0 *1 0,0
RVSS_t15 VSS__t15 VSS 0.516796306549
* device instance VSS_t16 r0 *1 0,0
RVSS_t16 VSS__t16 VSS 0.264203290494
* device instance VSS_t17 r0 *1 0,0
RVSS_t17 VSS__t17 VSS 0.422073922927
* device instance VSS_t18 r0 *1 0,0
RVSS_t18 VSS__t18 VSS 0.453648050599
* device instance VSS_t19 r0 *1 0,0
RVSS_t19 VSS__t19 VSS 0.177834614355
* device instance VSS_t20 r0 *1 0,0
RVSS_t20 VSS__t20 VSS 0.619872384706
* device instance VSS_t21 r0 *1 0,0
RVSS_t21 VSS__t21 VSS 0.643092820038
* device instance VSS_t22 r0 *1 0,0
RVSS_t22 VSS__t22 VSS 0.548370434757
* device instance VSS_t23 r0 *1 0,0
RVSS_t23 VSS__t23 VSS 0.651446513247
* device instance VSS_t24 r0 *1 0,0
RVSS_t24 VSS__t24 VSS 0.58829825625
* device instance VSS_t25 r0 *1 0,0
RVSS_t25 VSS__t25 VSS 0.209408735181
* device instance VSS_t26 r0 *1 0,0
RVSS_t26 VSS__t26 VSS 0.683020641861
* device instance VSS_t27 r0 *1 0,0
RVSS_t27 VSS__t27 VSS 0.714594770537
* device instance VSS_t28 r0 *1 0,0
RVSS_t28 VSS__t28 VSS 0.556724127891
* device instance VSS_t29 r0 *1 0,0
RVSS_t29 VSS__t29 VSS 0.240982858234
* device instance VSS_t30 r0 *1 0,0
RVSS_t30 VSS__t30 VSS 0.746168899268
* device instance VSS_t31 r0 *1 0,0
RVSS_t31 VSS__t31 VSS 0.525149999649
* device instance VSS_t32 r0 *1 0,0
RVSS_t32 VSS__t32 VSS 0.485222178486
* device instance VSS_t33 r0 *1 0,0
RVSS_t33 VSS__t33 VSS 0.201055043761
* device instance VSS_t34 r0 *1 0,0
RVSS_t34 VSS__t34 VSS 0.737815206011
* device instance VSS_t35 r0 *1 0,0
RVSS_t35 VSS__t35 VSS 0.232629166319
* device instance VSS_t36 r0 *1 0,0
RVSS_t36 VSS__t36 VSS 0.327351541825
* device instance VSS_t37 r0 *1 0,0
RVSS_t37 VSS__t37 VSS 0.927259979184
* device instance VSS_t38 r0 *1 0,0
RVSS_t38 VSS__t38 VSS 0.904039543546
* device instance VSS_t39 r0 *1 0,0
RVSS_t39 VSS__t39 VSS 0.769389334779
* device instance VSS_t40 r0 *1 0,0
RVSS_t40 VSS__t40 VSS 0.935613672496
* device instance VSS_t41 r0 *1 0,0
RVSS_t41 VSS__t41 VSS 0.958834108153
* device instance VSS_t42 r0 *1 0,0
RVSS_t42 VSS__t42 VSS 0.114686386741
* device instance VSS_t43 r0 *1 0,0
RVSS_t43 VSS__t43 VSS 0.967187801471
* device instance VSS_t44 r0 *1 0,0
RVSS_t44 VSS__t44 VSS 0.864111721325
* device instance VSS_t45 r0 *1 0,0
RVSS_t45 VSS__t45 VSS 0.0831122906191
* device instance VSS_t46 r0 *1 0,0
RVSS_t46 VSS__t46 VSS 0.0199644134456
* device instance VSS_t47 r0 *1 0,0
RVSS_t47 VSS__t47 VSS 0.83253759244
* device instance VSS_t48 r0 *1 0,0
RVSS_t48 VSS__t48 VSS 0.0515382351801
* device instance VSS_t49 r0 *1 0,0
RVSS_t49 VSS__t49 VSS 0.80096346359
* device instance VSS_t50 r0 *1 0,0
RVSS_t50 VSS__t50 VSS 0.89568585024
* device instance VSS_t51 r0 *1 0,0
RVSS_t51 VSS__t51 VSS 0.0116110812675
* device instance VSS_t52 r0 *1 0,0
RVSS_t52 VSS__t52 VSS 0.36727936123
* device instance VSS_t53 r0 *1 0,0
RVSS_t53 VSS__t53 VSS 0.0431845793935
* device instance VSS_t54 r0 *1 0,0
RVSS_t54 VSS__t54 VSS 0.674666948634
* device instance VSS_t55 r0 *1 0,0
RVSS_t55 VSS__t55 VSS 0.398853488394
* device instance VSS_t56 r0 *1 0,0
RVSS_t56 VSS__t56 VSS 0.0747586106868
* device instance VSS_t57 r0 *1 0,0
RVSS_t57 VSS__t57 VSS 0.493575871545
* device instance VSS_t58 r0 *1 0,0
RVSS_t58 VSS__t58 VSS 0.430427615875
* device instance VSS_t59 r0 *1 0,0
RVSS_t59 VSS__t59 VSS 0.706241077294
* device instance VSS_t60 r0 *1 0,0
RVSS_t60 VSS__t60 VSS 0.137906807941
* device instance VSS_t61 r0 *1 0,0
RVSS_t61 VSS__t61 VSS 0.990408237144
* device instance VSS_t62 r0 *1 0,0
RVSS_t62 VSS__t62 VSS 0.106332700198
* device instance VSS_t63 r0 *1 0,0
RVSS_t63 VSS__t63 VSS 0.462001743608
* device instance VSS_t64 r0 *1 0,0
RVSS_t64 VSS__t64 VSS 0.169480923724
* device instance VSS_t65 r0 *1 0,0
RVSS_t65 VSS__t65 VSS 0.304131108247
* device instance VSS_t66 r0 *1 0,0
RVSS_t66 VSS__t66 VSS 0.114686386741
* device instance VSS_t67 r0 *1 0,0
RVSS_t67 VSS__t67 VSS 0.809317156869
* device instance VSS_t68 r0 *1 0,0
RVSS_t68 VSS__t68 VSS 0.998761930468
* device instance VSS_t69 r0 *1 0,0
RVSS_t69 VSS__t69 VSS 0.146260497198
* device instance VSS_t70 r0 *1 0,0
RVSS_t70 VSS__t70 VSS 0.177834614355
* device instance VSS_t71 r0 *1 0,0
RVSS_t71 VSS__t71 VSS 0.967187801471
* device instance VSS_t72 r0 *1 0,0
RVSS_t72 VSS__t72 VSS 0.209408735181
* device instance VSS_t73 r0 *1 0,0
RVSS_t73 VSS__t73 VSS 0.935613672496
* device instance VSS_t74 r0 *1 0,0
RVSS_t74 VSS__t74 VSS 0.89568585024
* device instance VSS_t75 r0 *1 0,0
RVSS_t75 VSS__t75 VSS 0.904039543546
* device instance VSS_t76 r0 *1 0,0
RVSS_t76 VSS__t76 VSS 0.927259979184
* device instance VSS_t77 r0 *1 0,0
RVSS_t77 VSS__t77 VSS 0.958834108153
* device instance VSS_t78 r0 *1 0,0
RVSS_t78 VSS__t78 VSS 0.872465414622
* device instance VSS_t79 r0 *1 0,0
RVSS_t79 VSS__t79 VSS 0.840891285729
* device instance VSS_t80 r0 *1 0,0
RVSS_t80 VSS__t80 VSS 0.0116110812675
* device instance VSS_t81 r0 *1 0,0
RVSS_t81 VSS__t81 VSS 0.0431845793935
* device instance VSS_t82 r0 *1 0,0
RVSS_t82 VSS__t82 VSS 0.240982858234
* device instance VSS_t83 r0 *1 0,0
RVSS_t83 VSS__t83 VSS 0.516796306549
* device instance VSS_t84 r0 *1 0,0
RVSS_t84 VSS__t84 VSS 0.769389334779
* device instance VSS_t85 r0 *1 0,0
RVSS_t85 VSS__t85 VSS 0.80096346359
* device instance VSS_t86 r0 *1 0,0
RVSS_t86 VSS__t86 VSS 0.737815206011
* device instance VSS_t87 r0 *1 0,0
RVSS_t87 VSS__t87 VSS 0.548370434757
* device instance VSS_t88 r0 *1 0,0
RVSS_t88 VSS__t88 VSS 0.83253759244
* device instance VSS_t89 r0 *1 0,0
RVSS_t89 VSS__t89 VSS 0.706241077294
* device instance VSS_t90 r0 *1 0,0
RVSS_t90 VSS__t90 VSS 0.579944563086
* device instance VSS_t91 r0 *1 0,0
RVSS_t91 VSS__t91 VSS 0.864111721325
* device instance VSS_t92 r0 *1 0,0
RVSS_t92 VSS__t92 VSS 0.36727936123
* device instance VSS_t93 r0 *1 0,0
RVSS_t93 VSS__t93 VSS 0.643092820038
* device instance VSS_t94 r0 *1 0,0
RVSS_t94 VSS__t94 VSS 0.493575871545
* device instance VSS_t95 r0 *1 0,0
RVSS_t95 VSS__t95 VSS 0.611518691518
* device instance VSS_t96 r0 *1 0,0
RVSS_t96 VSS__t96 VSS 0.0199644134456
* device instance VSS_t97 r0 *1 0,0
RVSS_t97 VSS__t97 VSS 0.462001743608
* device instance VSS_t98 r0 *1 0,0
RVSS_t98 VSS__t98 VSS 0.430427615875
* device instance VSS_t99 r0 *1 0,0
RVSS_t99 VSS__t99 VSS 0.0515382351801
* device instance VSS_t100 r0 *1 0,0
RVSS_t100 VSS__t100 VSS 0.27255698274
* device instance VSS_t101 r0 *1 0,0
RVSS_t101 VSS__t101 VSS 0.398853488394
* device instance VSS_t102 r0 *1 0,0
RVSS_t102 VSS__t102 VSS 0.0831122906191
* device instance VSS_t103 r0 *1 0,0
RVSS_t103 VSS__t103 VSS 0.674666948634
* device instance VSS_t104 r0 *1 0,0
RVSS_t104 VSS__t104 VSS 0.58829825625
* device instance VSS_t105 r0 *1 0,0
RVSS_t105 VSS__t105 VSS 0.232629166319
* device instance VSS_t106 r0 *1 0,0
RVSS_t106 VSS__t106 VSS 0.453648050599
* device instance VSS_t107 r0 *1 0,0
RVSS_t107 VSS__t107 VSS 0.264203290494
* device instance VSS_t108 r0 *1 0,0
RVSS_t108 VSS__t108 VSS 0.485222178486
* device instance VSS_t109 r0 *1 0,0
RVSS_t109 VSS__t109 VSS 0.556724127891
* device instance VSS_t110 r0 *1 0,0
RVSS_t110 VSS__t110 VSS 0.714594770537
* device instance VSS_t111 r0 *1 0,0
RVSS_t111 VSS__t111 VSS 0.746168899268
* device instance VSS_t112 r0 *1 0,0
RVSS_t112 VSS__t112 VSS 0.201055043761
* device instance VSS_t113 r0 *1 0,0
RVSS_t113 VSS__t113 VSS 0.422073922927
* device instance VSS_t114 r0 *1 0,0
RVSS_t114 VSS__t114 VSS 0.295777415769
* device instance VSS_t115 r0 *1 0,0
RVSS_t115 VSS__t115 VSS 0.683020641861
* device instance VSS_t116 r0 *1 0,0
RVSS_t116 VSS__t116 VSS 0.169480923724
* device instance VSS_t117 r0 *1 0,0
RVSS_t117 VSS__t117 VSS 0.106332700198
* device instance VSS_t118 r0 *1 0,0
RVSS_t118 VSS__t118 VSS 0.335705234472
* device instance VSS_t119 r0 *1 0,0
RVSS_t119 VSS__t119 VSS 0.390499795523
* device instance VSS_t120 r0 *1 0,0
RVSS_t120 VSS__t120 VSS 0.777743028047
* device instance VSS_t121 r0 *1 0,0
RVSS_t121 VSS__t121 VSS 0.619872384706
* device instance VSS_t122 r0 *1 0,0
RVSS_t122 VSS__t122 VSS 0.525149999649
* device instance VSS_t123 r0 *1 0,0
RVSS_t123 VSS__t123 VSS 0.137906807941
* device instance VSS_t124 r0 *1 0,0
RVSS_t124 VSS__t124 VSS 0.0747586106868
* device instance VSS_t125 r0 *1 0,0
RVSS_t125 VSS__t125 VSS 0.651446513247
* device instance VSS_t126 r0 *1 0,0
RVSS_t126 VSS__t126 VSS 0.358925668456
* device instance VSS_t127 r0 *1 0,0
RVSS_t127 VSS__t127 VSS 0.327351541825
* device instance VSS_t128 r0 *1 0,0
RVSS_t128 VSS__t128 VSS 1.00485024536
* device instance VSS_t129 r0 *1 0,0
RVSS_t129 VSS__t129 VSS 0.97327611733
* device instance VSS_t130 r0 *1 0,0
RVSS_t130 VSS__t130 VSS 0.941701989386
* device instance VSS_t131 r0 *1 0,0
RVSS_t131 VSS__t131 VSS 0.910127861538
* device instance VSS_t132 r0 *1 0,0
RVSS_t132 VSS__t132 VSS 0.878553733797
* device instance VSS_t133 r0 *1 0,0
RVSS_t133 VSS__t133 VSS 0.846979606174
* device instance VSS_t134 r0 *1 0,0
RVSS_t134 VSS__t134 VSS 0.815405478682
* device instance VSS_t135 r0 *1 0,0
RVSS_t135 VSS__t135 VSS 0.783831351338
* device instance VSS_t136 r0 *1 0,0
RVSS_t136 VSS__t136 VSS 0.75225722416
* device instance VSS_t137 r0 *1 0,0
RVSS_t137 VSS__t137 VSS 0.720683097171
* device instance VSS_t138 r0 *1 0,0
RVSS_t138 VSS__t138 VSS 0.689108970395
* device instance VSS_t139 r0 *1 0,0
RVSS_t139 VSS__t139 VSS 0.657534843864
* device instance VSS_t140 r0 *1 0,0
RVSS_t140 VSS__t140 VSS 0.625960717615
* device instance VSS_t141 r0 *1 0,0
RVSS_t141 VSS__t141 VSS 0.594386591693
* device instance VSS_t142 r0 *1 0,0
RVSS_t142 VSS__t142 VSS 0.562812466153
* device instance VSS_t143 r0 *1 0,0
RVSS_t143 VSS__t143 VSS 0.531238341062
* device instance VSS_t144 r0 *1 0,0
RVSS_t144 VSS__t144 VSS 0.499664216506
* device instance VSS_t145 r0 *1 0,0
RVSS_t145 VSS__t145 VSS 0.468090092594
* device instance VSS_t146 r0 *1 0,0
RVSS_t146 VSS__t146 VSS 0.436515969465
* device instance VSS_t147 r0 *1 0,0
RVSS_t147 VSS__t147 VSS 0.404941847302
* device instance VSS_t148 r0 *1 0,0
RVSS_t148 VSS__t148 VSS 0.373367726351
* device instance VSS_t149 r0 *1 0,0
RVSS_t149 VSS__t149 VSS 0.341793606946
* device instance VSS_t150 r0 *1 0,0
RVSS_t150 VSS__t150 VSS 0.310219489561
* device instance VSS_t151 r0 *1 0,0
RVSS_t151 VSS__t151 VSS 0.278645374881
* device instance VSS_t152 r0 *1 0,0
RVSS_t152 VSS__t152 VSS 0.247071263945
* device instance VSS_t153 r0 *1 0,0
RVSS_t153 VSS__t153 VSS 0.215497158397
* device instance VSS_t154 r0 *1 0,0
RVSS_t154 VSS__t154 VSS 0.183923061012
* device instance VSS_t155 r0 *1 0,0
RVSS_t155 VSS__t155 VSS 0.152348976867
* device instance VSS_t156 r0 *1 0,0
RVSS_t156 VSS__t156 VSS 0.120774916344
* device instance VSS_t157 r0 *1 0,0
RVSS_t157 VSS__t157 VSS 0.0892009045275
* device instance VSS_t158 r0 *1 0,0
RVSS_t158 VSS__t158 VSS 0.0576270214782
* device instance VSS_t159 r0 *1 0,0
RVSS_t159 VSS__t159 VSS 0.0260537353483
* device instance VSS_t160 r0 *1 0,0
RVSS_t160 VSS__t160 VSS 0.00552918908801
* device instance VSS_t161 r0 *1 0,0
RVSS_t161 VSS__t161 VSS 0.0370971430648
* device instance VSS_t162 r0 *1 0,0
RVSS_t162 VSS__t162 VSS 0.0686707754463
* device instance VSS_t163 r0 *1 0,0
RVSS_t163 VSS__t163 VSS 0.100244720871
* device instance VSS_t164 r0 *1 0,0
RVSS_t164 VSS__t164 VSS 0.131818754393
* device instance VSS_t165 r0 *1 0,0
RVSS_t165 VSS__t165 VSS 0.163392824941
* device instance VSS_t166 r0 *1 0,0
RVSS_t166 VSS__t166 VSS 0.194966914526
* device instance VSS_t167 r0 *1 0,0
RVSS_t167 VSS__t167 VSS 0.226541015189
* device instance VSS_t168 r0 *1 0,0
RVSS_t168 VSS__t168 VSS 0.258115122864
* device instance VSS_t169 r0 *1 0,0
RVSS_t169 VSS__t169 VSS 0.289689235258
* device instance VSS_t170 r0 *1 0,0
RVSS_t170 VSS__t170 VSS 0.32126335098
* device instance VSS_t171 r0 *1 0,0
RVSS_t171 VSS__t171 VSS 0.352837469137
* device instance VSS_t172 r0 *1 0,0
RVSS_t172 VSS__t172 VSS 0.384411589128
* device instance VSS_t173 r0 *1 0,0
RVSS_t173 VSS__t173 VSS 0.415985710536
* device instance VSS_t174 r0 *1 0,0
RVSS_t174 VSS__t174 VSS 0.447559833061
* device instance VSS_t175 r0 *1 0,0
RVSS_t175 VSS__t175 VSS 0.479133956483
* device instance VSS_t176 r0 *1 0,0
RVSS_t176 VSS__t176 VSS 0.510708080634
* device instance VSS_t177 r0 *1 0,0
RVSS_t177 VSS__t177 VSS 0.542282205387
* device instance VSS_t178 r0 *1 0,0
RVSS_t178 VSS__t178 VSS 0.573856330644
* device instance VSS_t179 r0 *1 0,0
RVSS_t179 VSS__t179 VSS 0.605430456325
* device instance VSS_t180 r0 *1 0,0
RVSS_t180 VSS__t180 VSS 0.637004582367
* device instance VSS_t181 r0 *1 0,0
RVSS_t181 VSS__t181 VSS 0.668578708719
* device instance VSS_t182 r0 *1 0,0
RVSS_t182 VSS__t182 VSS 0.70015283534
* device instance VSS_t183 r0 *1 0,0
RVSS_t183 VSS__t183 VSS 0.731726962193
* device instance VSS_t184 r0 *1 0,0
RVSS_t184 VSS__t184 VSS 0.763301089251
* device instance VSS_t185 r0 *1 0,0
RVSS_t185 VSS__t185 VSS 0.79487521649
* device instance VSS_t186 r0 *1 0,0
RVSS_t186 VSS__t186 VSS 0.826449343887
* device instance VSS_t187 r0 *1 0,0
RVSS_t187 VSS__t187 VSS 0.858023471427
* device instance VSS_t188 r0 *1 0,0
RVSS_t188 VSS__t188 VSS 0.889597599093
* device instance VSS_t189 r0 *1 0,0
RVSS_t189 VSS__t189 VSS 0.921171726873
* device instance VSS_t190 r0 *1 0,0
RVSS_t190 VSS__t190 VSS 0.952745854755
* device instance VSS_t191 r0 *1 0,0
RVSS_t191 VSS__t191 VSS 0.98431998273
* device instance VSS_t192 r0 *1 0,0
RVSS_t192 VSS__t192 VSS 0.98431998273
* device instance VSS_t193 r0 *1 0,0
RVSS_t193 VSS__t193 VSS 0.952745854755
* device instance VSS_t194 r0 *1 0,0
RVSS_t194 VSS__t194 VSS 0.921171726873
* device instance VSS_t195 r0 *1 0,0
RVSS_t195 VSS__t195 VSS 0.889597599093
* device instance VSS_t196 r0 *1 0,0
RVSS_t196 VSS__t196 VSS 0.858023471427
* device instance VSS_t197 r0 *1 0,0
RVSS_t197 VSS__t197 VSS 0.826449343887
* device instance VSS_t198 r0 *1 0,0
RVSS_t198 VSS__t198 VSS 0.79487521649
* device instance VSS_t199 r0 *1 0,0
RVSS_t199 VSS__t199 VSS 0.763301089251
* device instance VSS_t200 r0 *1 0,0
RVSS_t200 VSS__t200 VSS 0.731726962193
* device instance VSS_t201 r0 *1 0,0
RVSS_t201 VSS__t201 VSS 0.70015283534
* device instance VSS_t202 r0 *1 0,0
RVSS_t202 VSS__t202 VSS 0.668578708719
* device instance VSS_t203 r0 *1 0,0
RVSS_t203 VSS__t203 VSS 0.637004582367
* device instance VSS_t204 r0 *1 0,0
RVSS_t204 VSS__t204 VSS 0.605430456325
* device instance VSS_t205 r0 *1 0,0
RVSS_t205 VSS__t205 VSS 0.573856330644
* device instance VSS_t206 r0 *1 0,0
RVSS_t206 VSS__t206 VSS 0.542282205387
* device instance VSS_t207 r0 *1 0,0
RVSS_t207 VSS__t207 VSS 0.510708080634
* device instance VSS_t208 r0 *1 0,0
RVSS_t208 VSS__t208 VSS 0.479133956483
* device instance VSS_t209 r0 *1 0,0
RVSS_t209 VSS__t209 VSS 0.447559833061
* device instance VSS_t210 r0 *1 0,0
RVSS_t210 VSS__t210 VSS 0.415985710536
* device instance VSS_t211 r0 *1 0,0
RVSS_t211 VSS__t211 VSS 0.384411589128
* device instance VSS_t212 r0 *1 0,0
RVSS_t212 VSS__t212 VSS 0.352837469137
* device instance VSS_t213 r0 *1 0,0
RVSS_t213 VSS__t213 VSS 0.32126335098
* device instance VSS_t214 r0 *1 0,0
RVSS_t214 VSS__t214 VSS 0.289689235258
* device instance VSS_t215 r0 *1 0,0
RVSS_t215 VSS__t215 VSS 0.258115122864
* device instance VSS_t216 r0 *1 0,0
RVSS_t216 VSS__t216 VSS 0.226541015189
* device instance VSS_t217 r0 *1 0,0
RVSS_t217 VSS__t217 VSS 0.194966914526
* device instance VSS_t218 r0 *1 0,0
RVSS_t218 VSS__t218 VSS 0.163392824941
* device instance VSS_t219 r0 *1 0,0
RVSS_t219 VSS__t219 VSS 0.131818754393
* device instance VSS_t220 r0 *1 0,0
RVSS_t220 VSS__t220 VSS 0.100244720871
* device instance VSS_t221 r0 *1 0,0
RVSS_t221 VSS__t221 VSS 0.0686707754463
* device instance VSS_t222 r0 *1 0,0
RVSS_t222 VSS__t222 VSS 0.0370971430648
* device instance VSS_t223 r0 *1 0,0
RVSS_t223 VSS__t223 VSS 0.00552918908801
* device instance VSS_t224 r0 *1 0,0
RVSS_t224 VSS__t224 VSS 0.0260537353483
* device instance VSS_t225 r0 *1 0,0
RVSS_t225 VSS__t225 VSS 0.0576270214782
* device instance VSS_t226 r0 *1 0,0
RVSS_t226 VSS__t226 VSS 0.0892009045275
* device instance VSS_t227 r0 *1 0,0
RVSS_t227 VSS__t227 VSS 0.120774916344
* device instance VSS_t228 r0 *1 0,0
RVSS_t228 VSS__t228 VSS 0.152348976867
* device instance VSS_t229 r0 *1 0,0
RVSS_t229 VSS__t229 VSS 0.183923061012
* device instance VSS_t230 r0 *1 0,0
RVSS_t230 VSS__t230 VSS 0.215497158397
* device instance VSS_t231 r0 *1 0,0
RVSS_t231 VSS__t231 VSS 0.247071263945
* device instance VSS_t232 r0 *1 0,0
RVSS_t232 VSS__t232 VSS 0.278645374881
* device instance VSS_t233 r0 *1 0,0
RVSS_t233 VSS__t233 VSS 0.310219489561
* device instance VSS_t234 r0 *1 0,0
RVSS_t234 VSS__t234 VSS 0.341793606946
* device instance VSS_t235 r0 *1 0,0
RVSS_t235 VSS__t235 VSS 0.373367726351
* device instance VSS_t236 r0 *1 0,0
RVSS_t236 VSS__t236 VSS 0.404941847302
* device instance VSS_t237 r0 *1 0,0
RVSS_t237 VSS__t237 VSS 0.436515969465
* device instance VSS_t238 r0 *1 0,0
RVSS_t238 VSS__t238 VSS 0.468090092594
* device instance VSS_t239 r0 *1 0,0
RVSS_t239 VSS__t239 VSS 0.499664216506
* device instance VSS_t240 r0 *1 0,0
RVSS_t240 VSS__t240 VSS 0.531238341062
* device instance VSS_t241 r0 *1 0,0
RVSS_t241 VSS__t241 VSS 0.562812466153
* device instance VSS_t242 r0 *1 0,0
RVSS_t242 VSS__t242 VSS 0.594386591693
* device instance VSS_t243 r0 *1 0,0
RVSS_t243 VSS__t243 VSS 0.625960717615
* device instance VSS_t244 r0 *1 0,0
RVSS_t244 VSS__t244 VSS 0.657534843864
* device instance VSS_t245 r0 *1 0,0
RVSS_t245 VSS__t245 VSS 0.689108970395
* device instance VSS_t246 r0 *1 0,0
RVSS_t246 VSS__t246 VSS 0.720683097171
* device instance VSS_t247 r0 *1 0,0
RVSS_t247 VSS__t247 VSS 0.75225722416
* device instance VSS_t248 r0 *1 0,0
RVSS_t248 VSS__t248 VSS 0.783831351338
* device instance VSS_t249 r0 *1 0,0
RVSS_t249 VSS__t249 VSS 0.815405478682
* device instance VSS_t250 r0 *1 0,0
RVSS_t250 VSS__t250 VSS 0.846979606174
* device instance VSS_t251 r0 *1 0,0
RVSS_t251 VSS__t251 VSS 0.878553733797
* device instance VSS_t252 r0 *1 0,0
RVSS_t252 VSS__t252 VSS 0.910127861538
* device instance VSS_t253 r0 *1 0,0
RVSS_t253 VSS__t253 VSS 0.941701989386
* device instance VSS_t254 r0 *1 0,0
RVSS_t254 VSS__t254 VSS 0.97327611733
* device instance VSS_t255 r0 *1 0,0
RVSS_t255 VSS__t255 VSS 1.00485024536
* device instance VSS_t256 r0 *1 0,0
RVSS_t256 VSS__t256 VSS 0.998761930468
* device instance VSS_t257 r0 *1 0,0
RVSS_t257 VSS__t257 VSS 0.967187801471
* device instance VSS_t258 r0 *1 0,0
RVSS_t258 VSS__t258 VSS 0.935613672496
* device instance VSS_t259 r0 *1 0,0
RVSS_t259 VSS__t259 VSS 0.904039543546
* device instance VSS_t260 r0 *1 0,0
RVSS_t260 VSS__t260 VSS 0.872465414622
* device instance VSS_t261 r0 *1 0,0
RVSS_t261 VSS__t261 VSS 0.840891285729
* device instance VSS_t262 r0 *1 0,0
RVSS_t262 VSS__t262 VSS 0.809317156869
* device instance VSS_t263 r0 *1 0,0
RVSS_t263 VSS__t263 VSS 0.777743028047
* device instance VSS_t264 r0 *1 0,0
RVSS_t264 VSS__t264 VSS 0.746168899268
* device instance VSS_t265 r0 *1 0,0
RVSS_t265 VSS__t265 VSS 0.714594770537
* device instance VSS_t266 r0 *1 0,0
RVSS_t266 VSS__t266 VSS 0.683020641861
* device instance VSS_t267 r0 *1 0,0
RVSS_t267 VSS__t267 VSS 0.651446513247
* device instance VSS_t268 r0 *1 0,0
RVSS_t268 VSS__t268 VSS 0.619872384706
* device instance VSS_t269 r0 *1 0,0
RVSS_t269 VSS__t269 VSS 0.58829825625
* device instance VSS_t270 r0 *1 0,0
RVSS_t270 VSS__t270 VSS 0.556724127891
* device instance VSS_t271 r0 *1 0,0
RVSS_t271 VSS__t271 VSS 0.525149999649
* device instance VSS_t272 r0 *1 0,0
RVSS_t272 VSS__t272 VSS 0.493575871545
* device instance VSS_t273 r0 *1 0,0
RVSS_t273 VSS__t273 VSS 0.462001743608
* device instance VSS_t274 r0 *1 0,0
RVSS_t274 VSS__t274 VSS 0.430427615875
* device instance VSS_t275 r0 *1 0,0
RVSS_t275 VSS__t275 VSS 0.398853488394
* device instance VSS_t276 r0 *1 0,0
RVSS_t276 VSS__t276 VSS 0.36727936123
* device instance VSS_t277 r0 *1 0,0
RVSS_t277 VSS__t277 VSS 0.335705234472
* device instance VSS_t278 r0 *1 0,0
RVSS_t278 VSS__t278 VSS 0.304131108247
* device instance VSS_t279 r0 *1 0,0
RVSS_t279 VSS__t279 VSS 0.27255698274
* device instance VSS_t280 r0 *1 0,0
RVSS_t280 VSS__t280 VSS 0.240982858234
* device instance VSS_t281 r0 *1 0,0
RVSS_t281 VSS__t281 VSS 0.209408735181
* device instance VSS_t282 r0 *1 0,0
RVSS_t282 VSS__t282 VSS 0.177834614355
* device instance VSS_t283 r0 *1 0,0
RVSS_t283 VSS__t283 VSS 0.146260497198
* device instance VSS_t284 r0 *1 0,0
RVSS_t284 VSS__t284 VSS 0.114686386741
* device instance VSS_t285 r0 *1 0,0
RVSS_t285 VSS__t285 VSS 0.0831122906191
* device instance VSS_t286 r0 *1 0,0
RVSS_t286 VSS__t286 VSS 0.0515382351801
* device instance VSS_t287 r0 *1 0,0
RVSS_t287 VSS__t287 VSS 0.0199644134456
* device instance VSS_t288 r0 *1 0,0
RVSS_t288 VSS__t288 VSS 0.0116110812675
* device instance VSS_t289 r0 *1 0,0
RVSS_t289 VSS__t289 VSS 0.0431845793935
* device instance VSS_t290 r0 *1 0,0
RVSS_t290 VSS__t290 VSS 0.0747586106868
* device instance VSS_t291 r0 *1 0,0
RVSS_t291 VSS__t291 VSS 0.106332700198
* device instance VSS_t292 r0 *1 0,0
RVSS_t292 VSS__t292 VSS 0.137906807941
* device instance VSS_t293 r0 *1 0,0
RVSS_t293 VSS__t293 VSS 0.169480923724
* device instance VSS_t294 r0 *1 0,0
RVSS_t294 VSS__t294 VSS 0.201055043761
* device instance VSS_t295 r0 *1 0,0
RVSS_t295 VSS__t295 VSS 0.232629166319
* device instance VSS_t296 r0 *1 0,0
RVSS_t296 VSS__t296 VSS 0.264203290494
* device instance VSS_t297 r0 *1 0,0
RVSS_t297 VSS__t297 VSS 0.295777415769
* device instance VSS_t298 r0 *1 0,0
RVSS_t298 VSS__t298 VSS 0.327351541825
* device instance VSS_t299 r0 *1 0,0
RVSS_t299 VSS__t299 VSS 0.358925668456
* device instance VSS_t300 r0 *1 0,0
RVSS_t300 VSS__t300 VSS 0.390499795523
* device instance VSS_t301 r0 *1 0,0
RVSS_t301 VSS__t301 VSS 0.422073922927
* device instance VSS_t302 r0 *1 0,0
RVSS_t302 VSS__t302 VSS 0.453648050599
* device instance VSS_t303 r0 *1 0,0
RVSS_t303 VSS__t303 VSS 0.485222178486
* device instance VSS_t304 r0 *1 0,0
RVSS_t304 VSS__t304 VSS 0.516796306549
* device instance VSS_t305 r0 *1 0,0
RVSS_t305 VSS__t305 VSS 0.548370434757
* device instance VSS_t306 r0 *1 0,0
RVSS_t306 VSS__t306 VSS 0.579944563086
* device instance VSS_t307 r0 *1 0,0
RVSS_t307 VSS__t307 VSS 0.611518691518
* device instance VSS_t308 r0 *1 0,0
RVSS_t308 VSS__t308 VSS 0.643092820038
* device instance VSS_t309 r0 *1 0,0
RVSS_t309 VSS__t309 VSS 0.674666948634
* device instance VSS_t310 r0 *1 0,0
RVSS_t310 VSS__t310 VSS 0.706241077294
* device instance VSS_t311 r0 *1 0,0
RVSS_t311 VSS__t311 VSS 0.737815206011
* device instance VSS_t312 r0 *1 0,0
RVSS_t312 VSS__t312 VSS 0.769389334779
* device instance VSS_t313 r0 *1 0,0
RVSS_t313 VSS__t313 VSS 0.80096346359
* device instance VSS_t314 r0 *1 0,0
RVSS_t314 VSS__t314 VSS 0.83253759244
* device instance VSS_t315 r0 *1 0,0
RVSS_t315 VSS__t315 VSS 0.864111721325
* device instance VSS_t316 r0 *1 0,0
RVSS_t316 VSS__t316 VSS 0.89568585024
* device instance VSS_t317 r0 *1 0,0
RVSS_t317 VSS__t317 VSS 0.927259979184
* device instance VSS_t318 r0 *1 0,0
RVSS_t318 VSS__t318 VSS 0.958834108153
* device instance VSS_t319 r0 *1 0,0
RVSS_t319 VSS__t319 VSS 0.990408237144
* device instance VSS_t320 r0 *1 0,0
RVSS_t320 VSS__t320 VSS 0.990408237144
* device instance VSS_t321 r0 *1 0,0
RVSS_t321 VSS__t321 VSS 0.958834108153
* device instance VSS_t322 r0 *1 0,0
RVSS_t322 VSS__t322 VSS 0.927259979184
* device instance VSS_t323 r0 *1 0,0
RVSS_t323 VSS__t323 VSS 0.89568585024
* device instance VSS_t324 r0 *1 0,0
RVSS_t324 VSS__t324 VSS 0.864111721325
* device instance VSS_t325 r0 *1 0,0
RVSS_t325 VSS__t325 VSS 0.83253759244
* device instance VSS_t326 r0 *1 0,0
RVSS_t326 VSS__t326 VSS 0.80096346359
* device instance VSS_t327 r0 *1 0,0
RVSS_t327 VSS__t327 VSS 0.769389334779
* device instance VSS_t328 r0 *1 0,0
RVSS_t328 VSS__t328 VSS 0.737815206011
* device instance VSS_t329 r0 *1 0,0
RVSS_t329 VSS__t329 VSS 0.706241077294
* device instance VSS_t330 r0 *1 0,0
RVSS_t330 VSS__t330 VSS 0.674666948634
* device instance VSS_t331 r0 *1 0,0
RVSS_t331 VSS__t331 VSS 0.643092820038
* device instance VSS_t332 r0 *1 0,0
RVSS_t332 VSS__t332 VSS 0.611518691518
* device instance VSS_t333 r0 *1 0,0
RVSS_t333 VSS__t333 VSS 0.579944563086
* device instance VSS_t334 r0 *1 0,0
RVSS_t334 VSS__t334 VSS 0.548370434757
* device instance VSS_t335 r0 *1 0,0
RVSS_t335 VSS__t335 VSS 0.516796306549
* device instance VSS_t336 r0 *1 0,0
RVSS_t336 VSS__t336 VSS 0.485222178486
* device instance VSS_t337 r0 *1 0,0
RVSS_t337 VSS__t337 VSS 0.453648050599
* device instance VSS_t338 r0 *1 0,0
RVSS_t338 VSS__t338 VSS 0.422073922927
* device instance VSS_t339 r0 *1 0,0
RVSS_t339 VSS__t339 VSS 0.390499795523
* device instance VSS_t340 r0 *1 0,0
RVSS_t340 VSS__t340 VSS 0.358925668456
* device instance VSS_t341 r0 *1 0,0
RVSS_t341 VSS__t341 VSS 0.327351541825
* device instance VSS_t342 r0 *1 0,0
RVSS_t342 VSS__t342 VSS 0.295777415769
* device instance VSS_t343 r0 *1 0,0
RVSS_t343 VSS__t343 VSS 0.264203290494
* device instance VSS_t344 r0 *1 0,0
RVSS_t344 VSS__t344 VSS 0.232629166319
* device instance VSS_t345 r0 *1 0,0
RVSS_t345 VSS__t345 VSS 0.201055043761
* device instance VSS_t346 r0 *1 0,0
RVSS_t346 VSS__t346 VSS 0.169480923724
* device instance VSS_t347 r0 *1 0,0
RVSS_t347 VSS__t347 VSS 0.137906807941
* device instance VSS_t348 r0 *1 0,0
RVSS_t348 VSS__t348 VSS 0.106332700198
* device instance VSS_t349 r0 *1 0,0
RVSS_t349 VSS__t349 VSS 0.0747586106868
* device instance VSS_t350 r0 *1 0,0
RVSS_t350 VSS__t350 VSS 0.0431845793935
* device instance VSS_t351 r0 *1 0,0
RVSS_t351 VSS__t351 VSS 0.0116110812675
* device instance VSS_t352 r0 *1 0,0
RVSS_t352 VSS__t352 VSS 0.0199644134456
* device instance VSS_t353 r0 *1 0,0
RVSS_t353 VSS__t353 VSS 0.0515382351801
* device instance VSS_t354 r0 *1 0,0
RVSS_t354 VSS__t354 VSS 0.0831122906191
* device instance VSS_t355 r0 *1 0,0
RVSS_t355 VSS__t355 VSS 0.114686386741
* device instance VSS_t356 r0 *1 0,0
RVSS_t356 VSS__t356 VSS 0.146260497198
* device instance VSS_t357 r0 *1 0,0
RVSS_t357 VSS__t357 VSS 0.177834614355
* device instance VSS_t358 r0 *1 0,0
RVSS_t358 VSS__t358 VSS 0.209408735181
* device instance VSS_t359 r0 *1 0,0
RVSS_t359 VSS__t359 VSS 0.240982858234
* device instance VSS_t360 r0 *1 0,0
RVSS_t360 VSS__t360 VSS 0.27255698274
* device instance VSS_t361 r0 *1 0,0
RVSS_t361 VSS__t361 VSS 0.304131108247
* device instance VSS_t362 r0 *1 0,0
RVSS_t362 VSS__t362 VSS 0.335705234472
* device instance VSS_t363 r0 *1 0,0
RVSS_t363 VSS__t363 VSS 0.36727936123
* device instance VSS_t364 r0 *1 0,0
RVSS_t364 VSS__t364 VSS 0.398853488394
* device instance VSS_t365 r0 *1 0,0
RVSS_t365 VSS__t365 VSS 0.430427615875
* device instance VSS_t366 r0 *1 0,0
RVSS_t366 VSS__t366 VSS 0.462001743608
* device instance VSS_t367 r0 *1 0,0
RVSS_t367 VSS__t367 VSS 0.493575871545
* device instance VSS_t368 r0 *1 0,0
RVSS_t368 VSS__t368 VSS 0.525149999649
* device instance VSS_t369 r0 *1 0,0
RVSS_t369 VSS__t369 VSS 0.556724127891
* device instance VSS_t370 r0 *1 0,0
RVSS_t370 VSS__t370 VSS 0.58829825625
* device instance VSS_t371 r0 *1 0,0
RVSS_t371 VSS__t371 VSS 0.619872384706
* device instance VSS_t372 r0 *1 0,0
RVSS_t372 VSS__t372 VSS 0.651446513247
* device instance VSS_t373 r0 *1 0,0
RVSS_t373 VSS__t373 VSS 0.683020641861
* device instance VSS_t374 r0 *1 0,0
RVSS_t374 VSS__t374 VSS 0.714594770537
* device instance VSS_t375 r0 *1 0,0
RVSS_t375 VSS__t375 VSS 0.746168899268
* device instance VSS_t376 r0 *1 0,0
RVSS_t376 VSS__t376 VSS 0.777743028047
* device instance VSS_t377 r0 *1 0,0
RVSS_t377 VSS__t377 VSS 0.809317156869
* device instance VSS_t378 r0 *1 0,0
RVSS_t378 VSS__t378 VSS 0.840891285729
* device instance VSS_t379 r0 *1 0,0
RVSS_t379 VSS__t379 VSS 0.872465414622
* device instance VSS_t380 r0 *1 0,0
RVSS_t380 VSS__t380 VSS 0.904039543546
* device instance VSS_t381 r0 *1 0,0
RVSS_t381 VSS__t381 VSS 0.935613672496
* device instance VSS_t382 r0 *1 0,0
RVSS_t382 VSS__t382 VSS 0.967187801471
* device instance VSS_t383 r0 *1 0,0
RVSS_t383 VSS__t383 VSS 0.998761930468
* device instance VSS r0 *1 0,0
CVSS VSS vsubs 6.9532971e-14
* device instance WL0_n0 r0 *1 0,0
CWL0_n0 WL0__t0 vsubs 2.83122158835e-16
* device instance WL0_n1 r0 *1 0,0
CWL0_n1 WL0__t1 vsubs 4.35422354622e-16
* device instance WL0_n2 r0 *1 0,0
CWL0_n2 WL0__t111 vsubs 4.35422354622e-16
* device instance WL0_n3 r0 *1 0,0
CWL0_n3 WL0__t44 vsubs 4.35422354622e-16
* device instance WL0_n4 r0 *1 0,0
CWL0_n4 WL0__t113 vsubs 4.35422354622e-16
* device instance WL0_n5 r0 *1 0,0
CWL0_n5 WL0__t42 vsubs 4.35422354622e-16
* device instance WL0_n6 r0 *1 0,0
CWL0_n6 WL0__t114 vsubs 4.35422354622e-16
* device instance WL0_n7 r0 *1 0,0
CWL0_n7 WL0__t41 vsubs 4.35422354622e-16
* device instance WL0_n8 r0 *1 0,0
CWL0_n8 WL0__t117 vsubs 4.35422354622e-16
* device instance WL0_n9 r0 *1 0,0
CWL0_n9 WL0__t27 vsubs 4.35422354622e-16
* device instance WL0_n10 r0 *1 0,0
CWL0_n10 WL0__t89 vsubs 4.35422354622e-16
* device instance WL0_n11 r0 *1 0,0
CWL0_n11 WL0__t26 vsubs 4.35422354622e-16
* device instance WL0_n12 r0 *1 0,0
CWL0_n12 WL0__t90 vsubs 4.35422354622e-16
* device instance WL0_n13 r0 *1 0,0
CWL0_n13 WL0__t24 vsubs 4.35422354622e-16
* device instance WL0_n14 r0 *1 0,0
CWL0_n14 WL0__t91 vsubs 4.35422354622e-16
* device instance WL0_n15 r0 *1 0,0
CWL0_n15 WL0__t36 vsubs 4.35422354622e-16
* device instance WL0_n16 r0 *1 0,0
CWL0_n16 WL0__t92 vsubs 4.35422354622e-16
* device instance WL0_n17 r0 *1 0,0
CWL0_n17 WL0__t51 vsubs 4.35422354622e-16
* device instance WL0_n18 r0 *1 0,0
CWL0_n18 WL0__t94 vsubs 4.35422354622e-16
* device instance WL0_n19 r0 *1 0,0
CWL0_n19 WL0__t56 vsubs 4.35422354622e-16
* device instance WL0_n20 r0 *1 0,0
CWL0_n20 WL0__t95 vsubs 4.35422354622e-16
* device instance WL0_n21 r0 *1 0,0
CWL0_n21 WL0__t60 vsubs 4.35422354622e-16
* device instance WL0_n22 r0 *1 0,0
CWL0_n22 WL0__t97 vsubs 4.35422354622e-16
* device instance WL0_n23 r0 *1 0,0
CWL0_n23 WL0__t63 vsubs 4.35422354622e-16
* device instance WL0_n24 r0 *1 0,0
CWL0_n24 WL0__t100 vsubs 4.35422354622e-16
* device instance WL0_n25 r0 *1 0,0
CWL0_n25 WL0__t13 vsubs 4.35422354622e-16
* device instance WL0_n26 r0 *1 0,0
CWL0_n26 WL0__t108 vsubs 4.35422354622e-16
* device instance WL0_n27 r0 *1 0,0
CWL0_n27 WL0__t22 vsubs 4.35422354622e-16
* device instance WL0_n28 r0 *1 0,0
CWL0_n28 WL0__t96 vsubs 4.35422354622e-16
* device instance WL0_n29 r0 *1 0,0
CWL0_n29 WL0__t16 vsubs 4.35422354622e-16
* device instance WL0_n30 r0 *1 0,0
CWL0_n30 WL0__t93 vsubs 4.35422354622e-16
* device instance WL0_n31 r0 *1 0,0
CWL0_n31 WL0__t3 vsubs 4.35422354622e-16
* device instance WL0_n32 r0 *1 0,0
CWL0_n32 WL0__t65 vsubs 4.35422354622e-16
* device instance WL0_n33 r0 *1 0,0
CWL0_n33 WL0__t40 vsubs 4.35422354622e-16
* device instance WL0_n34 r0 *1 0,0
CWL0_n34 WL0__t74 vsubs 4.35422354622e-16
* device instance WL0_n35 r0 *1 0,0
CWL0_n35 WL0__t38 vsubs 4.35422354622e-16
* device instance WL0_n36 r0 *1 0,0
CWL0_n36 WL0__t88 vsubs 4.35422354622e-16
* device instance WL0_n37 r0 *1 0,0
CWL0_n37 WL0__t35 vsubs 4.35422354622e-16
* device instance WL0_n38 r0 *1 0,0
CWL0_n38 WL0__t78 vsubs 4.35422354622e-16
* device instance WL0_n39 r0 *1 0,0
CWL0_n39 WL0__t31 vsubs 4.35422354622e-16
* device instance WL0_n40 r0 *1 0,0
CWL0_n40 WL0__t82 vsubs 4.35422354622e-16
* device instance WL0_n41 r0 *1 0,0
CWL0_n41 WL0__t28 vsubs 4.35422354622e-16
* device instance WL0_n42 r0 *1 0,0
CWL0_n42 WL0__t85 vsubs 4.35422354622e-16
* device instance WL0_n43 r0 *1 0,0
CWL0_n43 WL0__t25 vsubs 4.35422354622e-16
* device instance WL0_n44 r0 *1 0,0
CWL0_n44 WL0__t87 vsubs 4.35422354622e-16
* device instance WL0_n45 r0 *1 0,0
CWL0_n45 WL0__t52 vsubs 4.35422354622e-16
* device instance WL0_n46 r0 *1 0,0
CWL0_n46 WL0__t84 vsubs 4.35422354622e-16
* device instance WL0_n47 r0 *1 0,0
CWL0_n47 WL0__t57 vsubs 4.35422354622e-16
* device instance WL0_n48 r0 *1 0,0
CWL0_n48 WL0__t80 vsubs 4.35422354622e-16
* device instance WL0_n49 r0 *1 0,0
CWL0_n49 WL0__t58 vsubs 4.35422354622e-16
* device instance WL0_n50 r0 *1 0,0
CWL0_n50 WL0__t77 vsubs 4.35422354622e-16
* device instance WL0_n51 r0 *1 0,0
CWL0_n51 WL0__t61 vsubs 4.35422354622e-16
* device instance WL0_n52 r0 *1 0,0
CWL0_n52 WL0__t66 vsubs 4.35422354622e-16
* device instance WL0_n53 r0 *1 0,0
CWL0_n53 WL0__t64 vsubs 4.35422354622e-16
* device instance WL0_n54 r0 *1 0,0
CWL0_n54 WL0__t70 vsubs 4.35422354622e-16
* device instance WL0_n55 r0 *1 0,0
CWL0_n55 WL0__t50 vsubs 4.35422354622e-16
* device instance WL0_n56 r0 *1 0,0
CWL0_n56 WL0__t98 vsubs 4.35422354622e-16
* device instance WL0_n57 r0 *1 0,0
CWL0_n57 WL0__t43 vsubs 4.35422354622e-16
* device instance WL0_n58 r0 *1 0,0
CWL0_n58 WL0__t73 vsubs 4.35422354622e-16
* device instance WL0_n59 r0 *1 0,0
CWL0_n59 WL0__t45 vsubs 4.35422354622e-16
* device instance WL0_n60 r0 *1 0,0
CWL0_n60 WL0__t71 vsubs 4.35422354622e-16
* device instance WL0_n61 r0 *1 0,0
CWL0_n61 WL0__t47 vsubs 4.35422354622e-16
* device instance WL0_n62 r0 *1 0,0
CWL0_n62 WL0__t109 vsubs 4.35422354622e-16
* device instance WL0_n63 r0 *1 0,0
CWL0_n63 WL0__t46 vsubs 4.35422354622e-16
* device instance WL0_n64 r0 *1 0,0
CWL0_n64 WL0 vsubs 4.35422354622e-16
* device instance WL0_n65 r0 *1 0,0
CWL0_n65 WL0__t29 vsubs 4.35422354622e-16
* device instance WL0_n66 r0 *1 0,0
CWL0_n66 WL0__t125 vsubs 4.35422354622e-16
* device instance WL0_n67 r0 *1 0,0
CWL0_n67 WL0__t30 vsubs 4.35422354622e-16
* device instance WL0_n68 r0 *1 0,0
CWL0_n68 WL0__t124 vsubs 4.35422354622e-16
* device instance WL0_n69 r0 *1 0,0
CWL0_n69 WL0__t32 vsubs 4.35422354622e-16
* device instance WL0_n70 r0 *1 0,0
CWL0_n70 WL0__t123 vsubs 4.35422354622e-16
* device instance WL0_n71 r0 *1 0,0
CWL0_n71 WL0__t33 vsubs 4.35422354622e-16
* device instance WL0_n72 r0 *1 0,0
CWL0_n72 WL0__t122 vsubs 4.35422354622e-16
* device instance WL0_n73 r0 *1 0,0
CWL0_n73 WL0__t34 vsubs 4.35422354622e-16
* device instance WL0_n74 r0 *1 0,0
CWL0_n74 WL0__t121 vsubs 4.35422354622e-16
* device instance WL0_n75 r0 *1 0,0
CWL0_n75 WL0__t48 vsubs 4.35422354622e-16
* device instance WL0_n76 r0 *1 0,0
CWL0_n76 WL0__t119 vsubs 4.35422354622e-16
* device instance WL0_n77 r0 *1 0,0
CWL0_n77 WL0__t37 vsubs 4.35422354622e-16
* device instance WL0_n78 r0 *1 0,0
CWL0_n78 WL0__t118 vsubs 4.35422354622e-16
* device instance WL0_n79 r0 *1 0,0
CWL0_n79 WL0__t39 vsubs 4.35422354622e-16
* device instance WL0_n80 r0 *1 0,0
CWL0_n80 WL0__t101 vsubs 4.35422354622e-16
* device instance WL0_n81 r0 *1 0,0
CWL0_n81 WL0__t12 vsubs 4.35422354622e-16
* device instance WL0_n82 r0 *1 0,0
CWL0_n82 WL0__t104 vsubs 4.35422354622e-16
* device instance WL0_n83 r0 *1 0,0
CWL0_n83 WL0__t6 vsubs 4.35422354622e-16
* device instance WL0_n84 r0 *1 0,0
CWL0_n84 WL0__t106 vsubs 4.35422354622e-16
* device instance WL0_n85 r0 *1 0,0
CWL0_n85 WL0__t2 vsubs 4.35422354622e-16
* device instance WL0_n86 r0 *1 0,0
CWL0_n86 WL0__t107 vsubs 4.35422354622e-16
* device instance WL0_n87 r0 *1 0,0
CWL0_n87 WL0__t54 vsubs 4.35422354622e-16
* device instance WL0_n88 r0 *1 0,0
CWL0_n88 WL0__t105 vsubs 4.35422354622e-16
* device instance WL0_n89 r0 *1 0,0
CWL0_n89 WL0__t59 vsubs 4.35422354622e-16
* device instance WL0_n90 r0 *1 0,0
CWL0_n90 WL0__t103 vsubs 4.35422354622e-16
* device instance WL0_n91 r0 *1 0,0
CWL0_n91 WL0__t53 vsubs 4.35422354622e-16
* device instance WL0_n92 r0 *1 0,0
CWL0_n92 WL0__t102 vsubs 4.35422354622e-16
* device instance WL0_n93 r0 *1 0,0
CWL0_n93 WL0__t55 vsubs 4.35422354622e-16
* device instance WL0_n94 r0 *1 0,0
CWL0_n94 WL0__t99 vsubs 4.35422354622e-16
* device instance WL0_n95 r0 *1 0,0
CWL0_n95 WL0__t49 vsubs 4.35422354622e-16
* device instance WL0_n96 r0 *1 0,0
CWL0_n96 WL0__t116 vsubs 4.35422354622e-16
* device instance WL0_n97 r0 *1 0,0
CWL0_n97 WL0__t62 vsubs 4.35422354622e-16
* device instance WL0_n98 r0 *1 0,0
CWL0_n98 WL0__t68 vsubs 4.35422354622e-16
* device instance WL0_n99 r0 *1 0,0
CWL0_n99 WL0__t17 vsubs 4.35422354622e-16
* device instance WL0_n100 r0 *1 0,0
CWL0_n100 WL0__t75 vsubs 4.35422354622e-16
* device instance WL0_n101 r0 *1 0,0
CWL0_n101 WL0__t11 vsubs 4.35422354622e-16
* device instance WL0_n102 r0 *1 0,0
CWL0_n102 WL0__t81 vsubs 4.35422354622e-16
* device instance WL0_n103 r0 *1 0,0
CWL0_n103 WL0__t18 vsubs 4.35422354622e-16
* device instance WL0_n104 r0 *1 0,0
CWL0_n104 WL0__t86 vsubs 4.35422354622e-16
* device instance WL0_n105 r0 *1 0,0
CWL0_n105 WL0__t7 vsubs 4.35422354622e-16
* device instance WL0_n106 r0 *1 0,0
CWL0_n106 WL0__t83 vsubs 4.35422354622e-16
* device instance WL0_n107 r0 *1 0,0
CWL0_n107 WL0__t5 vsubs 4.35422354622e-16
* device instance WL0_n108 r0 *1 0,0
CWL0_n108 WL0__t79 vsubs 4.35422354622e-16
* device instance WL0_n109 r0 *1 0,0
CWL0_n109 WL0__t14 vsubs 4.35422354622e-16
* device instance WL0_n110 r0 *1 0,0
CWL0_n110 WL0__t76 vsubs 4.35422354622e-16
* device instance WL0_n111 r0 *1 0,0
CWL0_n111 WL0__t23 vsubs 4.35422354622e-16
* device instance WL0_n112 r0 *1 0,0
CWL0_n112 WL0__t67 vsubs 4.35422354622e-16
* device instance WL0_n113 r0 *1 0,0
CWL0_n113 WL0__t20 vsubs 4.35422354622e-16
* device instance WL0_n114 r0 *1 0,0
CWL0_n114 WL0__t69 vsubs 4.35422354622e-16
* device instance WL0_n115 r0 *1 0,0
CWL0_n115 WL0__t8 vsubs 4.35422354622e-16
* device instance WL0_n116 r0 *1 0,0
CWL0_n116 WL0__t72 vsubs 4.35422354622e-16
* device instance WL0_n117 r0 *1 0,0
CWL0_n117 WL0__t4 vsubs 4.35422354622e-16
* device instance WL0_n118 r0 *1 0,0
CWL0_n118 WL0__t110 vsubs 4.35422354622e-16
* device instance WL0_n119 r0 *1 0,0
CWL0_n119 WL0__t9 vsubs 4.35422354622e-16
* device instance WL0_n120 r0 *1 0,0
CWL0_n120 WL0__t112 vsubs 4.35422354622e-16
* device instance WL0_n121 r0 *1 0,0
CWL0_n121 WL0__t15 vsubs 4.35422354622e-16
* device instance WL0_n122 r0 *1 0,0
CWL0_n122 WL0__t115 vsubs 4.35422354622e-16
* device instance WL0_n123 r0 *1 0,0
CWL0_n123 WL0__t21 vsubs 4.35422354622e-16
* device instance WL0_n124 r0 *1 0,0
CWL0_n124 WL0__t127 vsubs 4.35422354622e-16
* device instance WL0_n125 r0 *1 0,0
CWL0_n125 WL0__t10 vsubs 4.35422354622e-16
* device instance WL0_n126 r0 *1 0,0
CWL0_n126 WL0__t120 vsubs 4.35422354622e-16
* device instance WL0_n127 r0 *1 0,0
CWL0_n127 WL0__t19 vsubs 2.83122158835e-16
* device instance WL0_seg0 r0 *1 0,0
RWL0_seg0 WL0__t0 WL0__t1 112.263599056
* device instance WL0_seg1 r0 *1 0,0
RWL0_seg1 WL0__t1 WL0__t111 60.3900739749
* device instance WL0_seg2 r0 *1 0,0
RWL0_seg2 WL0__t111 WL0__t44 112.263599056
* device instance WL0_seg3 r0 *1 0,0
RWL0_seg3 WL0__t44 WL0__t113 60.3900739749
* device instance WL0_seg4 r0 *1 0,0
RWL0_seg4 WL0__t113 WL0__t42 112.263599056
* device instance WL0_seg5 r0 *1 0,0
RWL0_seg5 WL0__t42 WL0__t114 60.3900739749
* device instance WL0_seg6 r0 *1 0,0
RWL0_seg6 WL0__t114 WL0__t41 112.263599056
* device instance WL0_seg7 r0 *1 0,0
RWL0_seg7 WL0__t41 WL0__t117 60.3900739749
* device instance WL0_seg8 r0 *1 0,0
RWL0_seg8 WL0__t117 WL0__t27 112.263599056
* device instance WL0_seg9 r0 *1 0,0
RWL0_seg9 WL0__t27 WL0__t89 60.3900739749
* device instance WL0_seg10 r0 *1 0,0
RWL0_seg10 WL0__t89 WL0__t26 112.263599056
* device instance WL0_seg11 r0 *1 0,0
RWL0_seg11 WL0__t26 WL0__t90 60.3900739749
* device instance WL0_seg12 r0 *1 0,0
RWL0_seg12 WL0__t90 WL0__t24 112.263599056
* device instance WL0_seg13 r0 *1 0,0
RWL0_seg13 WL0__t24 WL0__t91 60.3900739749
* device instance WL0_seg14 r0 *1 0,0
RWL0_seg14 WL0__t91 WL0__t36 112.263599056
* device instance WL0_seg15 r0 *1 0,0
RWL0_seg15 WL0__t36 WL0__t92 60.3900739749
* device instance WL0_seg16 r0 *1 0,0
RWL0_seg16 WL0__t92 WL0__t51 112.263599056
* device instance WL0_seg17 r0 *1 0,0
RWL0_seg17 WL0__t51 WL0__t94 60.3900739749
* device instance WL0_seg18 r0 *1 0,0
RWL0_seg18 WL0__t94 WL0__t56 112.263599056
* device instance WL0_seg19 r0 *1 0,0
RWL0_seg19 WL0__t56 WL0__t95 60.3900739749
* device instance WL0_seg20 r0 *1 0,0
RWL0_seg20 WL0__t95 WL0__t60 112.263599056
* device instance WL0_seg21 r0 *1 0,0
RWL0_seg21 WL0__t60 WL0__t97 60.3900739749
* device instance WL0_seg22 r0 *1 0,0
RWL0_seg22 WL0__t97 WL0__t63 112.263599056
* device instance WL0_seg23 r0 *1 0,0
RWL0_seg23 WL0__t63 WL0__t100 60.3900739749
* device instance WL0_seg24 r0 *1 0,0
RWL0_seg24 WL0__t100 WL0__t13 112.263599056
* device instance WL0_seg25 r0 *1 0,0
RWL0_seg25 WL0__t13 WL0__t108 60.3900739749
* device instance WL0_seg26 r0 *1 0,0
RWL0_seg26 WL0__t108 WL0__t22 112.263599056
* device instance WL0_seg27 r0 *1 0,0
RWL0_seg27 WL0__t22 WL0__t96 60.3900739749
* device instance WL0_seg28 r0 *1 0,0
RWL0_seg28 WL0__t96 WL0__t16 112.263599056
* device instance WL0_seg29 r0 *1 0,0
RWL0_seg29 WL0__t16 WL0__t93 60.3900739749
* device instance WL0_seg30 r0 *1 0,0
RWL0_seg30 WL0__t93 WL0__t3 112.263599056
* device instance WL0_seg31 r0 *1 0,0
RWL0_seg31 WL0__t3 WL0__t65 60.3900739749
* device instance WL0_seg32 r0 *1 0,0
RWL0_seg32 WL0__t65 WL0__t40 112.263599056
* device instance WL0_seg33 r0 *1 0,0
RWL0_seg33 WL0__t40 WL0__t74 60.3900739749
* device instance WL0_seg34 r0 *1 0,0
RWL0_seg34 WL0__t74 WL0__t38 112.263599056
* device instance WL0_seg35 r0 *1 0,0
RWL0_seg35 WL0__t38 WL0__t88 60.3900739749
* device instance WL0_seg36 r0 *1 0,0
RWL0_seg36 WL0__t88 WL0__t35 112.263599056
* device instance WL0_seg37 r0 *1 0,0
RWL0_seg37 WL0__t35 WL0__t78 60.3900739749
* device instance WL0_seg38 r0 *1 0,0
RWL0_seg38 WL0__t78 WL0__t31 112.263599056
* device instance WL0_seg39 r0 *1 0,0
RWL0_seg39 WL0__t31 WL0__t82 60.3900739749
* device instance WL0_seg40 r0 *1 0,0
RWL0_seg40 WL0__t82 WL0__t28 112.263599056
* device instance WL0_seg41 r0 *1 0,0
RWL0_seg41 WL0__t28 WL0__t85 60.3900739749
* device instance WL0_seg42 r0 *1 0,0
RWL0_seg42 WL0__t85 WL0__t25 112.263599056
* device instance WL0_seg43 r0 *1 0,0
RWL0_seg43 WL0__t25 WL0__t87 60.3900739749
* device instance WL0_seg44 r0 *1 0,0
RWL0_seg44 WL0__t87 WL0__t52 112.263599056
* device instance WL0_seg45 r0 *1 0,0
RWL0_seg45 WL0__t52 WL0__t84 60.3900739749
* device instance WL0_seg46 r0 *1 0,0
RWL0_seg46 WL0__t84 WL0__t57 112.263599056
* device instance WL0_seg47 r0 *1 0,0
RWL0_seg47 WL0__t57 WL0__t80 60.3900739749
* device instance WL0_seg48 r0 *1 0,0
RWL0_seg48 WL0__t80 WL0__t58 112.263599056
* device instance WL0_seg49 r0 *1 0,0
RWL0_seg49 WL0__t58 WL0__t77 60.3900739749
* device instance WL0_seg50 r0 *1 0,0
RWL0_seg50 WL0__t77 WL0__t61 112.263599056
* device instance WL0_seg51 r0 *1 0,0
RWL0_seg51 WL0__t61 WL0__t66 60.3900739749
* device instance WL0_seg52 r0 *1 0,0
RWL0_seg52 WL0__t66 WL0__t64 112.263599056
* device instance WL0_seg53 r0 *1 0,0
RWL0_seg53 WL0__t64 WL0__t70 60.3900739749
* device instance WL0_seg54 r0 *1 0,0
RWL0_seg54 WL0__t70 WL0__t50 112.263599056
* device instance WL0_seg55 r0 *1 0,0
RWL0_seg55 WL0__t50 WL0__t98 60.3900739749
* device instance WL0_seg56 r0 *1 0,0
RWL0_seg56 WL0__t98 WL0__t43 112.263599056
* device instance WL0_seg57 r0 *1 0,0
RWL0_seg57 WL0__t43 WL0__t73 60.3900739749
* device instance WL0_seg58 r0 *1 0,0
RWL0_seg58 WL0__t73 WL0__t45 112.263599056
* device instance WL0_seg59 r0 *1 0,0
RWL0_seg59 WL0__t45 WL0__t71 60.3900739749
* device instance WL0_seg60 r0 *1 0,0
RWL0_seg60 WL0__t71 WL0__t47 112.263599056
* device instance WL0_seg61 r0 *1 0,0
RWL0_seg61 WL0__t47 WL0__t109 60.3900739749
* device instance WL0_seg62 r0 *1 0,0
RWL0_seg62 WL0__t109 WL0__t46 112.263599056
* device instance WL0_seg63 r0 *1 0,0
RWL0_seg63 WL0__t46 WL0 60.3900739749
* device instance WL0_seg64 r0 *1 0,0
RWL0_seg64 WL0 WL0__t29 112.263599056
* device instance WL0_seg65 r0 *1 0,0
RWL0_seg65 WL0__t29 WL0__t125 60.3900739749
* device instance WL0_seg66 r0 *1 0,0
RWL0_seg66 WL0__t125 WL0__t30 112.263599056
* device instance WL0_seg67 r0 *1 0,0
RWL0_seg67 WL0__t30 WL0__t124 60.3900739749
* device instance WL0_seg68 r0 *1 0,0
RWL0_seg68 WL0__t124 WL0__t32 112.263599056
* device instance WL0_seg69 r0 *1 0,0
RWL0_seg69 WL0__t32 WL0__t123 60.3900739749
* device instance WL0_seg70 r0 *1 0,0
RWL0_seg70 WL0__t123 WL0__t33 112.263599056
* device instance WL0_seg71 r0 *1 0,0
RWL0_seg71 WL0__t33 WL0__t122 60.3900739749
* device instance WL0_seg72 r0 *1 0,0
RWL0_seg72 WL0__t122 WL0__t34 112.263599056
* device instance WL0_seg73 r0 *1 0,0
RWL0_seg73 WL0__t34 WL0__t121 60.3900739749
* device instance WL0_seg74 r0 *1 0,0
RWL0_seg74 WL0__t121 WL0__t48 112.263599056
* device instance WL0_seg75 r0 *1 0,0
RWL0_seg75 WL0__t48 WL0__t119 60.3900739749
* device instance WL0_seg76 r0 *1 0,0
RWL0_seg76 WL0__t119 WL0__t37 112.263599056
* device instance WL0_seg77 r0 *1 0,0
RWL0_seg77 WL0__t37 WL0__t118 60.3900739749
* device instance WL0_seg78 r0 *1 0,0
RWL0_seg78 WL0__t118 WL0__t39 112.263599056
* device instance WL0_seg79 r0 *1 0,0
RWL0_seg79 WL0__t39 WL0__t101 60.3900739749
* device instance WL0_seg80 r0 *1 0,0
RWL0_seg80 WL0__t101 WL0__t12 112.263599056
* device instance WL0_seg81 r0 *1 0,0
RWL0_seg81 WL0__t12 WL0__t104 60.3900739749
* device instance WL0_seg82 r0 *1 0,0
RWL0_seg82 WL0__t104 WL0__t6 112.263599056
* device instance WL0_seg83 r0 *1 0,0
RWL0_seg83 WL0__t6 WL0__t106 60.3900739749
* device instance WL0_seg84 r0 *1 0,0
RWL0_seg84 WL0__t106 WL0__t2 112.263599056
* device instance WL0_seg85 r0 *1 0,0
RWL0_seg85 WL0__t2 WL0__t107 60.3900739749
* device instance WL0_seg86 r0 *1 0,0
RWL0_seg86 WL0__t107 WL0__t54 112.263599056
* device instance WL0_seg87 r0 *1 0,0
RWL0_seg87 WL0__t54 WL0__t105 60.3900739749
* device instance WL0_seg88 r0 *1 0,0
RWL0_seg88 WL0__t105 WL0__t59 112.263599056
* device instance WL0_seg89 r0 *1 0,0
RWL0_seg89 WL0__t59 WL0__t103 60.3900739749
* device instance WL0_seg90 r0 *1 0,0
RWL0_seg90 WL0__t103 WL0__t53 112.263599056
* device instance WL0_seg91 r0 *1 0,0
RWL0_seg91 WL0__t53 WL0__t102 60.3900739749
* device instance WL0_seg92 r0 *1 0,0
RWL0_seg92 WL0__t102 WL0__t55 112.263599056
* device instance WL0_seg93 r0 *1 0,0
RWL0_seg93 WL0__t55 WL0__t99 60.3900739749
* device instance WL0_seg94 r0 *1 0,0
RWL0_seg94 WL0__t99 WL0__t49 112.263599056
* device instance WL0_seg95 r0 *1 0,0
RWL0_seg95 WL0__t49 WL0__t116 60.3900739749
* device instance WL0_seg96 r0 *1 0,0
RWL0_seg96 WL0__t116 WL0__t62 112.263599056
* device instance WL0_seg97 r0 *1 0,0
RWL0_seg97 WL0__t62 WL0__t68 60.3900739749
* device instance WL0_seg98 r0 *1 0,0
RWL0_seg98 WL0__t68 WL0__t17 112.263599056
* device instance WL0_seg99 r0 *1 0,0
RWL0_seg99 WL0__t17 WL0__t75 60.3900739749
* device instance WL0_seg100 r0 *1 0,0
RWL0_seg100 WL0__t75 WL0__t11 112.263599056
* device instance WL0_seg101 r0 *1 0,0
RWL0_seg101 WL0__t11 WL0__t81 60.3900739749
* device instance WL0_seg102 r0 *1 0,0
RWL0_seg102 WL0__t81 WL0__t18 112.263599056
* device instance WL0_seg103 r0 *1 0,0
RWL0_seg103 WL0__t18 WL0__t86 60.3900739749
* device instance WL0_seg104 r0 *1 0,0
RWL0_seg104 WL0__t86 WL0__t7 112.263599056
* device instance WL0_seg105 r0 *1 0,0
RWL0_seg105 WL0__t7 WL0__t83 60.3900739749
* device instance WL0_seg106 r0 *1 0,0
RWL0_seg106 WL0__t83 WL0__t5 112.263599056
* device instance WL0_seg107 r0 *1 0,0
RWL0_seg107 WL0__t5 WL0__t79 60.3900739749
* device instance WL0_seg108 r0 *1 0,0
RWL0_seg108 WL0__t79 WL0__t14 112.263599056
* device instance WL0_seg109 r0 *1 0,0
RWL0_seg109 WL0__t14 WL0__t76 60.3900739749
* device instance WL0_seg110 r0 *1 0,0
RWL0_seg110 WL0__t76 WL0__t23 112.263599056
* device instance WL0_seg111 r0 *1 0,0
RWL0_seg111 WL0__t23 WL0__t67 60.3900739749
* device instance WL0_seg112 r0 *1 0,0
RWL0_seg112 WL0__t67 WL0__t20 112.263599056
* device instance WL0_seg113 r0 *1 0,0
RWL0_seg113 WL0__t20 WL0__t69 60.3900739749
* device instance WL0_seg114 r0 *1 0,0
RWL0_seg114 WL0__t69 WL0__t8 112.263599056
* device instance WL0_seg115 r0 *1 0,0
RWL0_seg115 WL0__t8 WL0__t72 60.3900739749
* device instance WL0_seg116 r0 *1 0,0
RWL0_seg116 WL0__t72 WL0__t4 112.263599056
* device instance WL0_seg117 r0 *1 0,0
RWL0_seg117 WL0__t4 WL0__t110 60.3900739749
* device instance WL0_seg118 r0 *1 0,0
RWL0_seg118 WL0__t110 WL0__t9 112.263599056
* device instance WL0_seg119 r0 *1 0,0
RWL0_seg119 WL0__t9 WL0__t112 60.3900739749
* device instance WL0_seg120 r0 *1 0,0
RWL0_seg120 WL0__t112 WL0__t15 112.263599056
* device instance WL0_seg121 r0 *1 0,0
RWL0_seg121 WL0__t15 WL0__t115 60.3900739749
* device instance WL0_seg122 r0 *1 0,0
RWL0_seg122 WL0__t115 WL0__t21 112.263599056
* device instance WL0_seg123 r0 *1 0,0
RWL0_seg123 WL0__t21 WL0__t127 60.3900739749
* device instance WL0_seg124 r0 *1 0,0
RWL0_seg124 WL0__t127 WL0__t10 112.263599056
* device instance WL0_seg125 r0 *1 0,0
RWL0_seg125 WL0__t10 WL0__t120 60.3900739749
* device instance WL0_seg126 r0 *1 0,0
RWL0_seg126 WL0__t120 WL0__t19 112.263599056
* device instance cc__10_VSS r0 *1 0,0
Ccc__10_VSS \$10 VSS 7.862e-18
* device instance cc__102_VDD r0 *1 0,0
Ccc__102_VDD \$102 VDD 1.6433e-17
* device instance cc__102_VSS r0 *1 0,0
Ccc__102_VSS \$102 VSS 7.862e-18
* device instance cc__105_VDD r0 *1 0,0
Ccc__105_VDD \$105 VDD 1.6433e-17
* device instance cc__105_VSS r0 *1 0,0
Ccc__105_VSS \$105 VSS 7.862e-18
* device instance cc__108_VDD r0 *1 0,0
Ccc__108_VDD \$108 VDD 1.6433e-17
* device instance cc__108_VSS r0 *1 0,0
Ccc__108_VSS \$108 VSS 7.862e-18
* device instance cc__11_VSS r0 *1 0,0
Ccc__11_VSS \$11 VSS 7.862e-18
* device instance cc__111_VDD r0 *1 0,0
Ccc__111_VDD \$111 VDD 1.6433e-17
* device instance cc__111_VSS r0 *1 0,0
Ccc__111_VSS \$111 VSS 7.862e-18
* device instance cc__114_VDD r0 *1 0,0
Ccc__114_VDD \$114 VDD 1.6433e-17
* device instance cc__114_VSS r0 *1 0,0
Ccc__114_VSS \$114 VSS 7.862e-18
* device instance cc__117_VDD r0 *1 0,0
Ccc__117_VDD \$117 VDD 1.6433e-17
* device instance cc__117_VSS r0 *1 0,0
Ccc__117_VSS \$117 VSS 7.862e-18
* device instance cc__12_VSS r0 *1 0,0
Ccc__12_VSS \$12 VSS 7.862e-18
* device instance cc__120_VDD r0 *1 0,0
Ccc__120_VDD \$120 VDD 1.6433e-17
* device instance cc__120_VSS r0 *1 0,0
Ccc__120_VSS \$120 VSS 7.862e-18
* device instance cc__123_VDD r0 *1 0,0
Ccc__123_VDD \$123 VDD 1.6433e-17
* device instance cc__123_VSS r0 *1 0,0
Ccc__123_VSS \$123 VSS 7.862e-18
* device instance cc__126_VDD r0 *1 0,0
Ccc__126_VDD \$126 VDD 1.6433e-17
* device instance cc__126_VSS r0 *1 0,0
Ccc__126_VSS \$126 VSS 7.862e-18
* device instance cc__129_VDD r0 *1 0,0
Ccc__129_VDD \$129 VDD 1.6433e-17
* device instance cc__129_VSS r0 *1 0,0
Ccc__129_VSS \$129 VSS 7.862e-18
* device instance cc__13_VSS r0 *1 0,0
Ccc__13_VSS \$13 VSS 7.862e-18
* device instance cc__132_VDD r0 *1 0,0
Ccc__132_VDD \$132 VDD 1.6433e-17
* device instance cc__132_VSS r0 *1 0,0
Ccc__132_VSS \$132 VSS 7.862e-18
* device instance cc__135_VDD r0 *1 0,0
Ccc__135_VDD \$135 VDD 1.6433e-17
* device instance cc__135_VSS r0 *1 0,0
Ccc__135_VSS \$135 VSS 7.862e-18
* device instance cc__138_VDD r0 *1 0,0
Ccc__138_VDD \$138 VDD 1.6433e-17
* device instance cc__138_VSS r0 *1 0,0
Ccc__138_VSS \$138 VSS 7.862e-18
* device instance cc__14_VSS r0 *1 0,0
Ccc__14_VSS \$14 VSS 7.862e-18
* device instance cc__141_VDD r0 *1 0,0
Ccc__141_VDD \$141 VDD 1.6433e-17
* device instance cc__141_VSS r0 *1 0,0
Ccc__141_VSS \$141 VSS 7.862e-18
* device instance cc__144_VDD r0 *1 0,0
Ccc__144_VDD \$144 VDD 1.6433e-17
* device instance cc__144_VSS r0 *1 0,0
Ccc__144_VSS \$144 VSS 7.862e-18
* device instance cc__147_VDD r0 *1 0,0
Ccc__147_VDD \$147 VDD 1.6433e-17
* device instance cc__147_VSS r0 *1 0,0
Ccc__147_VSS \$147 VSS 7.862e-18
* device instance cc__15_VSS r0 *1 0,0
Ccc__15_VSS \$15 VSS 7.862e-18
* device instance cc__150_VDD r0 *1 0,0
Ccc__150_VDD \$150 VDD 1.6433e-17
* device instance cc__150_VSS r0 *1 0,0
Ccc__150_VSS \$150 VSS 7.862e-18
* device instance cc__153_VDD r0 *1 0,0
Ccc__153_VDD \$153 VDD 1.6433e-17
* device instance cc__153_VSS r0 *1 0,0
Ccc__153_VSS \$153 VSS 7.862e-18
* device instance cc__156_VDD r0 *1 0,0
Ccc__156_VDD \$156 VDD 1.6433e-17
* device instance cc__156_VSS r0 *1 0,0
Ccc__156_VSS \$156 VSS 7.862e-18
* device instance cc__159_VDD r0 *1 0,0
Ccc__159_VDD \$159 VDD 1.6433e-17
* device instance cc__159_VSS r0 *1 0,0
Ccc__159_VSS \$159 VSS 7.862e-18
* device instance cc__16_VSS r0 *1 0,0
Ccc__16_VSS \$16 VSS 7.862e-18
* device instance cc__162_VDD r0 *1 0,0
Ccc__162_VDD \$162 VDD 1.6433e-17
* device instance cc__162_VSS r0 *1 0,0
Ccc__162_VSS \$162 VSS 7.862e-18
* device instance cc__165_VDD r0 *1 0,0
Ccc__165_VDD \$165 VDD 1.6433e-17
* device instance cc__165_VSS r0 *1 0,0
Ccc__165_VSS \$165 VSS 7.862e-18
* device instance cc__168_VDD r0 *1 0,0
Ccc__168_VDD \$168 VDD 1.6433e-17
* device instance cc__168_VSS r0 *1 0,0
Ccc__168_VSS \$168 VSS 7.862e-18
* device instance cc__17_VSS r0 *1 0,0
Ccc__17_VSS \$17 VSS 7.862e-18
* device instance cc__171_VDD r0 *1 0,0
Ccc__171_VDD \$171 VDD 1.6433e-17
* device instance cc__171_VSS r0 *1 0,0
Ccc__171_VSS \$171 VSS 7.862e-18
* device instance cc__174_VDD r0 *1 0,0
Ccc__174_VDD \$174 VDD 1.6433e-17
* device instance cc__174_VSS r0 *1 0,0
Ccc__174_VSS \$174 VSS 7.862e-18
* device instance cc__177_VDD r0 *1 0,0
Ccc__177_VDD \$177 VDD 1.6433e-17
* device instance cc__177_VSS r0 *1 0,0
Ccc__177_VSS \$177 VSS 7.862e-18
* device instance cc__18_VSS r0 *1 0,0
Ccc__18_VSS \$18 VSS 7.862e-18
* device instance cc__180_VDD r0 *1 0,0
Ccc__180_VDD \$180 VDD 1.6433e-17
* device instance cc__180_VSS r0 *1 0,0
Ccc__180_VSS \$180 VSS 7.862e-18
* device instance cc__183_VDD r0 *1 0,0
Ccc__183_VDD \$183 VDD 1.6433e-17
* device instance cc__183_VSS r0 *1 0,0
Ccc__183_VSS \$183 VSS 7.862e-18
* device instance cc__186_VDD r0 *1 0,0
Ccc__186_VDD \$186 VDD 1.6433e-17
* device instance cc__186_VSS r0 *1 0,0
Ccc__186_VSS \$186 VSS 7.862e-18
* device instance cc__189_VDD r0 *1 0,0
Ccc__189_VDD \$189 VDD 1.6433e-17
* device instance cc__189_VSS r0 *1 0,0
Ccc__189_VSS \$189 VSS 7.862e-18
* device instance cc__19_VSS r0 *1 0,0
Ccc__19_VSS \$19 VSS 7.862e-18
* device instance cc__192_VDD r0 *1 0,0
Ccc__192_VDD \$192 VDD 1.6433e-17
* device instance cc__192_VSS r0 *1 0,0
Ccc__192_VSS \$192 VSS 7.862e-18
* device instance cc__195_VDD r0 *1 0,0
Ccc__195_VDD \$195 VDD 1.6433e-17
* device instance cc__195_VSS r0 *1 0,0
Ccc__195_VSS \$195 VSS 7.862e-18
* device instance cc__198_VDD r0 *1 0,0
Ccc__198_VDD \$198 VDD 1.6433e-17
* device instance cc__198_VSS r0 *1 0,0
Ccc__198_VSS \$198 VSS 7.862e-18
* device instance cc__20_VSS r0 *1 0,0
Ccc__20_VSS \$20 VSS 7.862e-18
* device instance cc__201_VDD r0 *1 0,0
Ccc__201_VDD \$201 VDD 1.6433e-17
* device instance cc__201_VSS r0 *1 0,0
Ccc__201_VSS \$201 VSS 7.862e-18
* device instance cc__204_VDD r0 *1 0,0
Ccc__204_VDD \$204 VDD 1.6433e-17
* device instance cc__204_VSS r0 *1 0,0
Ccc__204_VSS \$204 VSS 7.862e-18
* device instance cc__207_VDD r0 *1 0,0
Ccc__207_VDD \$207 VDD 1.6433e-17
* device instance cc__207_VSS r0 *1 0,0
Ccc__207_VSS \$207 VSS 7.862e-18
* device instance cc__21_VSS r0 *1 0,0
Ccc__21_VSS \$21 VSS 7.862e-18
* device instance cc__210_VDD r0 *1 0,0
Ccc__210_VDD \$210 VDD 1.6433e-17
* device instance cc__210_VSS r0 *1 0,0
Ccc__210_VSS \$210 VSS 7.862e-18
* device instance cc__213_VDD r0 *1 0,0
Ccc__213_VDD \$213 VDD 1.6433e-17
* device instance cc__213_VSS r0 *1 0,0
Ccc__213_VSS \$213 VSS 7.862e-18
* device instance cc__216_VDD r0 *1 0,0
Ccc__216_VDD \$216 VDD 1.6433e-17
* device instance cc__216_VSS r0 *1 0,0
Ccc__216_VSS \$216 VSS 7.862e-18
* device instance cc__219_VDD r0 *1 0,0
Ccc__219_VDD \$219 VDD 1.6433e-17
* device instance cc__219_VSS r0 *1 0,0
Ccc__219_VSS \$219 VSS 7.862e-18
* device instance cc__22_VSS r0 *1 0,0
Ccc__22_VSS \$22 VSS 7.862e-18
* device instance cc__222_VDD r0 *1 0,0
Ccc__222_VDD \$222 VDD 1.6433e-17
* device instance cc__222_VSS r0 *1 0,0
Ccc__222_VSS \$222 VSS 7.862e-18
* device instance cc__225_VDD r0 *1 0,0
Ccc__225_VDD \$225 VDD 1.6433e-17
* device instance cc__225_VSS r0 *1 0,0
Ccc__225_VSS \$225 VSS 7.862e-18
* device instance cc__228_VDD r0 *1 0,0
Ccc__228_VDD \$228 VDD 1.6433e-17
* device instance cc__228_VSS r0 *1 0,0
Ccc__228_VSS \$228 VSS 7.862e-18
* device instance cc__23_VSS r0 *1 0,0
Ccc__23_VSS \$23 VSS 7.862e-18
* device instance cc__231_VDD r0 *1 0,0
Ccc__231_VDD \$231 VDD 1.6433e-17
* device instance cc__231_VSS r0 *1 0,0
Ccc__231_VSS \$231 VSS 7.862e-18
* device instance cc__234_VDD r0 *1 0,0
Ccc__234_VDD \$234 VDD 1.6433e-17
* device instance cc__234_VSS r0 *1 0,0
Ccc__234_VSS \$234 VSS 7.862e-18
* device instance cc__237_VDD r0 *1 0,0
Ccc__237_VDD \$237 VDD 1.6433e-17
* device instance cc__237_VSS r0 *1 0,0
Ccc__237_VSS \$237 VSS 7.862e-18
* device instance cc__24_VSS r0 *1 0,0
Ccc__24_VSS \$24 VSS 7.862e-18
* device instance cc__240_VDD r0 *1 0,0
Ccc__240_VDD \$240 VDD 1.6433e-17
* device instance cc__240_VSS r0 *1 0,0
Ccc__240_VSS \$240 VSS 7.862e-18
* device instance cc__243_VDD r0 *1 0,0
Ccc__243_VDD \$243 VDD 1.6433e-17
* device instance cc__243_VSS r0 *1 0,0
Ccc__243_VSS \$243 VSS 7.862e-18
* device instance cc__246_VDD r0 *1 0,0
Ccc__246_VDD \$246 VDD 1.6433e-17
* device instance cc__246_VSS r0 *1 0,0
Ccc__246_VSS \$246 VSS 7.862e-18
* device instance cc__249_VDD r0 *1 0,0
Ccc__249_VDD \$249 VDD 1.6433e-17
* device instance cc__249_VSS r0 *1 0,0
Ccc__249_VSS \$249 VSS 7.862e-18
* device instance cc__25_VSS r0 *1 0,0
Ccc__25_VSS \$25 VSS 7.862e-18
* device instance cc__252_VDD r0 *1 0,0
Ccc__252_VDD \$252 VDD 1.6433e-17
* device instance cc__252_VSS r0 *1 0,0
Ccc__252_VSS \$252 VSS 7.862e-18
* device instance cc__255_VDD r0 *1 0,0
Ccc__255_VDD \$255 VDD 1.6433e-17
* device instance cc__255_VSS r0 *1 0,0
Ccc__255_VSS \$255 VSS 7.862e-18
* device instance cc__258_VDD r0 *1 0,0
Ccc__258_VDD \$258 VDD 1.6433e-17
* device instance cc__258_VSS r0 *1 0,0
Ccc__258_VSS \$258 VSS 7.862e-18
* device instance cc__26_VSS r0 *1 0,0
Ccc__26_VSS \$26 VSS 7.862e-18
* device instance cc__27_VSS r0 *1 0,0
Ccc__27_VSS \$27 VSS 7.862e-18
* device instance cc__28_VSS r0 *1 0,0
Ccc__28_VSS \$28 VSS 7.862e-18
* device instance cc__29_VSS r0 *1 0,0
Ccc__29_VSS \$29 VSS 7.862e-18
* device instance cc__30_VSS r0 *1 0,0
Ccc__30_VSS \$30 VSS 7.862e-18
* device instance cc__31_VSS r0 *1 0,0
Ccc__31_VSS \$31 VSS 7.862e-18
* device instance cc__32_VSS r0 *1 0,0
Ccc__32_VSS \$32 VSS 7.862e-18
* device instance cc__33_VSS r0 *1 0,0
Ccc__33_VSS \$33 VSS 7.862e-18
* device instance cc__34_VSS r0 *1 0,0
Ccc__34_VSS \$34 VSS 7.862e-18
* device instance cc__35_VSS r0 *1 0,0
Ccc__35_VSS \$35 VSS 7.862e-18
* device instance cc__36_VSS r0 *1 0,0
Ccc__36_VSS \$36 VSS 7.862e-18
* device instance cc__37_VSS r0 *1 0,0
Ccc__37_VSS \$37 VSS 7.862e-18
* device instance cc__38_VSS r0 *1 0,0
Ccc__38_VSS \$38 VSS 7.862e-18
* device instance cc__39_VSS r0 *1 0,0
Ccc__39_VSS \$39 VSS 7.862e-18
* device instance cc__4_VSS r0 *1 0,0
Ccc__4_VSS \$4 VSS 7.862e-18
* device instance cc__40_VSS r0 *1 0,0
Ccc__40_VSS \$40 VSS 7.862e-18
* device instance cc__41_VSS r0 *1 0,0
Ccc__41_VSS \$41 VSS 7.862e-18
* device instance cc__42_VSS r0 *1 0,0
Ccc__42_VSS \$42 VSS 7.862e-18
* device instance cc__43_VSS r0 *1 0,0
Ccc__43_VSS \$43 VSS 7.862e-18
* device instance cc__44_VSS r0 *1 0,0
Ccc__44_VSS \$44 VSS 7.862e-18
* device instance cc__45_VSS r0 *1 0,0
Ccc__45_VSS \$45 VSS 7.862e-18
* device instance cc__46_VSS r0 *1 0,0
Ccc__46_VSS \$46 VSS 7.862e-18
* device instance cc__47_VSS r0 *1 0,0
Ccc__47_VSS \$47 VSS 7.862e-18
* device instance cc__48_VSS r0 *1 0,0
Ccc__48_VSS \$48 VSS 7.862e-18
* device instance cc__49_VSS r0 *1 0,0
Ccc__49_VSS \$49 VSS 7.862e-18
* device instance cc__5_VSS r0 *1 0,0
Ccc__5_VSS \$5 VSS 7.862e-18
* device instance cc__50_VSS r0 *1 0,0
Ccc__50_VSS \$50 VSS 7.862e-18
* device instance cc__51_VSS r0 *1 0,0
Ccc__51_VSS \$51 VSS 7.862e-18
* device instance cc__52_VSS r0 *1 0,0
Ccc__52_VSS \$52 VSS 7.862e-18
* device instance cc__53_VSS r0 *1 0,0
Ccc__53_VSS \$53 VSS 7.862e-18
* device instance cc__54_VSS r0 *1 0,0
Ccc__54_VSS \$54 VSS 7.862e-18
* device instance cc__55_VSS r0 *1 0,0
Ccc__55_VSS \$55 VSS 7.862e-18
* device instance cc__56_VSS r0 *1 0,0
Ccc__56_VSS \$56 VSS 7.862e-18
* device instance cc__57_VSS r0 *1 0,0
Ccc__57_VSS \$57 VSS 7.862e-18
* device instance cc__58_VSS r0 *1 0,0
Ccc__58_VSS \$58 VSS 7.862e-18
* device instance cc__59_VSS r0 *1 0,0
Ccc__59_VSS \$59 VSS 7.862e-18
* device instance cc__6_VSS r0 *1 0,0
Ccc__6_VSS \$6 VSS 7.862e-18
* device instance cc__60_VSS r0 *1 0,0
Ccc__60_VSS \$60 VSS 7.862e-18
* device instance cc__61_VSS r0 *1 0,0
Ccc__61_VSS \$61 VSS 7.862e-18
* device instance cc__62_VSS r0 *1 0,0
Ccc__62_VSS \$62 VSS 7.862e-18
* device instance cc__63_VSS r0 *1 0,0
Ccc__63_VSS \$63 VSS 7.862e-18
* device instance cc__64_VSS r0 *1 0,0
Ccc__64_VSS \$64 VSS 7.862e-18
* device instance cc__65_VSS r0 *1 0,0
Ccc__65_VSS \$65 VSS 7.862e-18
* device instance cc__66_VSS r0 *1 0,0
Ccc__66_VSS \$66 VSS 7.862e-18
* device instance cc__67_VSS r0 *1 0,0
Ccc__67_VSS \$67 VSS 7.862e-18
* device instance cc__69_VDD r0 *1 0,0
Ccc__69_VDD \$69 VDD 1.6433e-17
* device instance cc__69_VSS r0 *1 0,0
Ccc__69_VSS \$69 VSS 7.862e-18
* device instance cc__7_VSS r0 *1 0,0
Ccc__7_VSS \$7 VSS 7.862e-18
* device instance cc__72_VDD r0 *1 0,0
Ccc__72_VDD \$72 VDD 1.6433e-17
* device instance cc__72_VSS r0 *1 0,0
Ccc__72_VSS \$72 VSS 7.862e-18
* device instance cc__75_VDD r0 *1 0,0
Ccc__75_VDD \$75 VDD 1.6433e-17
* device instance cc__75_VSS r0 *1 0,0
Ccc__75_VSS \$75 VSS 7.862e-18
* device instance cc__78_VDD r0 *1 0,0
Ccc__78_VDD \$78 VDD 1.6433e-17
* device instance cc__78_VSS r0 *1 0,0
Ccc__78_VSS \$78 VSS 7.862e-18
* device instance cc__8_VSS r0 *1 0,0
Ccc__8_VSS \$8 VSS 7.862e-18
* device instance cc__81_VDD r0 *1 0,0
Ccc__81_VDD \$81 VDD 1.6433e-17
* device instance cc__81_VSS r0 *1 0,0
Ccc__81_VSS \$81 VSS 7.862e-18
* device instance cc__84_VDD r0 *1 0,0
Ccc__84_VDD \$84 VDD 1.6433e-17
* device instance cc__84_VSS r0 *1 0,0
Ccc__84_VSS \$84 VSS 7.862e-18
* device instance cc__87_VDD r0 *1 0,0
Ccc__87_VDD \$87 VDD 1.6433e-17
* device instance cc__87_VSS r0 *1 0,0
Ccc__87_VSS \$87 VSS 7.862e-18
* device instance cc__9_VSS r0 *1 0,0
Ccc__9_VSS \$9 VSS 7.862e-18
* device instance cc__90_VDD r0 *1 0,0
Ccc__90_VDD \$90 VDD 1.6433e-17
* device instance cc__90_VSS r0 *1 0,0
Ccc__90_VSS \$90 VSS 7.862e-18
* device instance cc__93_VDD r0 *1 0,0
Ccc__93_VDD \$93 VDD 1.6433e-17
* device instance cc__93_VSS r0 *1 0,0
Ccc__93_VSS \$93 VSS 7.862e-18
* device instance cc__96_VDD r0 *1 0,0
Ccc__96_VDD \$96 VDD 1.6433e-17
* device instance cc__96_VSS r0 *1 0,0
Ccc__96_VSS \$96 VSS 7.862e-18
* device instance cc__99_VDD r0 *1 0,0
Ccc__99_VDD \$99 VDD 1.6433e-17
* device instance cc__99_VSS r0 *1 0,0
Ccc__99_VSS \$99 VSS 7.862e-18
* device instance cc_VDD_VSS r0 *1 0,0
Ccc_VDD_VSS VDD VSS 3.243557e-15
* device instance vsubs_dctie r0 *1 0,0
Rvsubs_dctie vsubs 0 1e+12
.ENDS wl_row_64
