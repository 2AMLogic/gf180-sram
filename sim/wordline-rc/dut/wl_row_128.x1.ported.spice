* extracted by klt extract --deck gf180mcu
* parasitic model (--parasitics):
* - capacitance: net-to-ground for every net's own (non-coupled) area/perimeter, plus net-to-net for the vertical-overlap coupling `coupling` describes below -- a coupled net pair gets a direct capacitor between their two hub nodes, not just capacitors to the deck's ground/substrate net
* - coupling: vertical overlap (crossover) unconditionally -- where one net's conductor on an adjacent metal level sits directly over another *distinct* net's conductor, that overlap area is charged between the two nets instead of to ground (issue #760) -- plus lateral (same-layer, sidewall) coupling, but only for a net pair naming one of the caller's declared `--critical-net` nets (issue #976): facing-edge length within that layer's own minimum-spacing lookback is charged between the two nets, *additively* (not deducted from either net's substrate fringe term, unlike the vertical case -- a known simplification). Any same-layer pair with neither side named `--critical-net`, and fringe shielding in general, are still not modelled
* - resistance: single lumped series resistance per net, distributed as a star across that net's device terminals (issue #592) -- not a per-segment, distributed RC ladder, *unless* `--distributed-rc` names this net via `--critical-net` (issue #977, Epic #709 Phase 2b): then the net's terminals are ordered along their approximate physical spread and its total R/C is broken into a chain of per-segment resistors (segment length proportional to inter-terminal distance) with a ground capacitor at each terminal node (proportional to its adjacent segment length/2), instead of one star hub -- still an approximation (terminal position is a device-placement proxy, not true per-segment routing geometry), but a strictly finer-grained one than the single-hub star
* - frequency: quasi-static -- one frequency-independent R and C per net; no skin effect, no distributed transmission-line behavior
* - substrate tie: 1e+12 ohm to ground -- the substrate is capacitively floating in transient analysis (DC reference only); see --substrate-tie-ohms
.GLOBAL vsubs

* cell wl_row_128
* pin BL0
* pin BL1
* pin BL10
* pin BL100
* pin BL101
* pin BL102
* pin BL103
* pin BL104
* pin BL105
* pin BL106
* pin BL107
* pin BL108
* pin BL109
* pin BL11
* pin BL110
* pin BL111
* pin BL112
* pin BL113
* pin BL114
* pin BL115
* pin BL116
* pin BL117
* pin BL118
* pin BL119
* pin BL12
* pin BL120
* pin BL121
* pin BL122
* pin BL123
* pin BL124
* pin BL125
* pin BL126
* pin BL127
* pin BL13
* pin BL14
* pin BL15
* pin BL16
* pin BL17
* pin BL18
* pin BL19
* pin BL2
* pin BL20
* pin BL21
* pin BL22
* pin BL23
* pin BL24
* pin BL25
* pin BL26
* pin BL27
* pin BL28
* pin BL29
* pin BL3
* pin BL30
* pin BL31
* pin BL32
* pin BL33
* pin BL34
* pin BL35
* pin BL36
* pin BL37
* pin BL38
* pin BL39
* pin BL4
* pin BL40
* pin BL41
* pin BL42
* pin BL43
* pin BL44
* pin BL45
* pin BL46
* pin BL47
* pin BL48
* pin BL49
* pin BL5
* pin BL50
* pin BL51
* pin BL52
* pin BL53
* pin BL54
* pin BL55
* pin BL56
* pin BL57
* pin BL58
* pin BL59
* pin BL6
* pin BL60
* pin BL61
* pin BL62
* pin BL63
* pin BL64
* pin BL65
* pin BL66
* pin BL67
* pin BL68
* pin BL69
* pin BL7
* pin BL70
* pin BL71
* pin BL72
* pin BL73
* pin BL74
* pin BL75
* pin BL76
* pin BL77
* pin BL78
* pin BL79
* pin BL8
* pin BL80
* pin BL81
* pin BL82
* pin BL83
* pin BL84
* pin BL85
* pin BL86
* pin BL87
* pin BL88
* pin BL89
* pin BL9
* pin BL90
* pin BL91
* pin BL92
* pin BL93
* pin BL94
* pin BL95
* pin BL96
* pin BL97
* pin BL98
* pin BL99
* pin BLB0
* pin BLB1
* pin BLB10
* pin BLB100
* pin BLB101
* pin BLB102
* pin BLB103
* pin BLB104
* pin BLB105
* pin BLB106
* pin BLB107
* pin BLB108
* pin BLB109
* pin BLB11
* pin BLB110
* pin BLB111
* pin BLB112
* pin BLB113
* pin BLB114
* pin BLB115
* pin BLB116
* pin BLB117
* pin BLB118
* pin BLB119
* pin BLB12
* pin BLB120
* pin BLB121
* pin BLB122
* pin BLB123
* pin BLB124
* pin BLB125
* pin BLB126
* pin BLB127
* pin BLB13
* pin BLB14
* pin BLB15
* pin BLB16
* pin BLB17
* pin BLB18
* pin BLB19
* pin BLB2
* pin BLB20
* pin BLB21
* pin BLB22
* pin BLB23
* pin BLB24
* pin BLB25
* pin BLB26
* pin BLB27
* pin BLB28
* pin BLB29
* pin BLB3
* pin BLB30
* pin BLB31
* pin BLB32
* pin BLB33
* pin BLB34
* pin BLB35
* pin BLB36
* pin BLB37
* pin BLB38
* pin BLB39
* pin BLB4
* pin BLB40
* pin BLB41
* pin BLB42
* pin BLB43
* pin BLB44
* pin BLB45
* pin BLB46
* pin BLB47
* pin BLB48
* pin BLB49
* pin BLB5
* pin BLB50
* pin BLB51
* pin BLB52
* pin BLB53
* pin BLB54
* pin BLB55
* pin BLB56
* pin BLB57
* pin BLB58
* pin BLB59
* pin BLB6
* pin BLB60
* pin BLB61
* pin BLB62
* pin BLB63
* pin BLB64
* pin BLB65
* pin BLB66
* pin BLB67
* pin BLB68
* pin BLB69
* pin BLB7
* pin BLB70
* pin BLB71
* pin BLB72
* pin BLB73
* pin BLB74
* pin BLB75
* pin BLB76
* pin BLB77
* pin BLB78
* pin BLB79
* pin BLB8
* pin BLB80
* pin BLB81
* pin BLB82
* pin BLB83
* pin BLB84
* pin BLB85
* pin BLB86
* pin BLB87
* pin BLB88
* pin BLB89
* pin BLB9
* pin BLB90
* pin BLB91
* pin BLB92
* pin BLB93
* pin BLB94
* pin BLB95
* pin BLB96
* pin BLB97
* pin BLB98
* pin BLB99
* pin VDD
* pin VSS
* pin WL0
.SUBCKT wl_row_128 BL0 BL1 BL10 BL100 BL101 BL102 BL103 BL104 BL105 BL106 BL107
+ BL108 BL109 BL11 BL110 BL111 BL112 BL113 BL114 BL115 BL116 BL117 BL118 BL119
+ BL12 BL120 BL121 BL122 BL123 BL124 BL125 BL126 BL127 BL13 BL14 BL15 BL16 BL17
+ BL18 BL19 BL2 BL20 BL21 BL22 BL23 BL24 BL25 BL26 BL27 BL28 BL29 BL3 BL30 BL31
+ BL32 BL33 BL34 BL35 BL36 BL37 BL38 BL39 BL4 BL40 BL41 BL42 BL43 BL44 BL45
+ BL46 BL47 BL48 BL49 BL5 BL50 BL51 BL52 BL53 BL54 BL55 BL56 BL57 BL58 BL59 BL6
+ BL60 BL61 BL62 BL63 BL64 BL65 BL66 BL67 BL68 BL69 BL7 BL70 BL71 BL72 BL73
+ BL74 BL75 BL76 BL77 BL78 BL79 BL8 BL80 BL81 BL82 BL83 BL84 BL85 BL86 BL87
+ BL88 BL89 BL9 BL90 BL91 BL92 BL93 BL94 BL95 BL96 BL97 BL98 BL99 BLB0 BLB1
+ BLB10 BLB100 BLB101 BLB102 BLB103 BLB104 BLB105 BLB106 BLB107 BLB108 BLB109
+ BLB11 BLB110 BLB111 BLB112 BLB113 BLB114 BLB115 BLB116 BLB117 BLB118 BLB119
+ BLB12 BLB120 BLB121 BLB122 BLB123 BLB124 BLB125 BLB126 BLB127 BLB13 BLB14
+ BLB15 BLB16 BLB17 BLB18 BLB19 BLB2 BLB20 BLB21 BLB22 BLB23 BLB24 BLB25 BLB26
+ BLB27 BLB28 BLB29 BLB3 BLB30 BLB31 BLB32 BLB33 BLB34 BLB35 BLB36 BLB37 BLB38
+ BLB39 BLB4 BLB40 BLB41 BLB42 BLB43 BLB44 BLB45 BLB46 BLB47 BLB48 BLB49 BLB5
+ BLB50 BLB51 BLB52 BLB53 BLB54 BLB55 BLB56 BLB57 BLB58 BLB59 BLB6 BLB60 BLB61
+ BLB62 BLB63 BLB64 BLB65 BLB66 BLB67 BLB68 BLB69 BLB7 BLB70 BLB71 BLB72 BLB73
+ BLB74 BLB75 BLB76 BLB77 BLB78 BLB79 BLB8 BLB80 BLB81 BLB82 BLB83 BLB84 BLB85
+ BLB86 BLB87 BLB88 BLB89 BLB9 BLB90 BLB91 BLB92 BLB93 BLB94 BLB95 BLB96 BLB97
+ BLB98 BLB99 VDD VSS WL0 WL0__t0 WL0__t3
* device instance $1 r0 *1 1.21,1.77 nfet
X$1 \$133__t4 WL0__t0 BL0__t0 VSS__t256 nfet_03v3 L=0.28U W=0.24U AS=0.1684P
+ AD=0.1022P PS=1.72U PD=0.96U
* device instance $2 r0 *1 4.11,1.77 nfet
X$2 BLB0__t0 WL0__t1 \$4__t3 VSS__t384 nfet_03v3 L=0.28U W=0.24U AS=0.1022P
+ AD=0.1684P PS=0.96U PD=1.72U
* device instance $3 r0 *1 2.07,1.83 nfet
X$3 VSS__t1 \$4__t0 \$133__t3 VSS__t512 nfet_03v3 L=0.28U W=0.36U AS=0.1022P
+ AD=0.169P PS=0.96U PD=1.28U
* device instance $4 r0 *1 3.25,1.83 nfet
X$4 \$4__t4 \$133__t0 VSS__t0 VSS__t640 nfet_03v3 L=0.28U W=0.36U AS=0.169P
+ AD=0.1022P PS=1.28U PD=0.96U
* device instance $5 r0 *1 5.67,1.77 nfet
X$5 \$136__t3 WL0__t233 BL1__t0 VSS__t257 nfet_03v3 L=0.28U W=0.24U AS=0.1684P
+ AD=0.1022P PS=1.72U PD=0.96U
* device instance $6 r0 *1 8.57,1.77 nfet
X$6 BLB1__t0 WL0__t51 \$5__t4 VSS__t385 nfet_03v3 L=0.28U W=0.24U AS=0.1022P
+ AD=0.1684P PS=0.96U PD=1.72U
* device instance $7 r0 *1 6.53,1.83 nfet
X$7 VSS__t90 \$5__t2 \$136__t4 VSS__t513 nfet_03v3 L=0.28U W=0.36U AS=0.1022P
+ AD=0.169P PS=0.96U PD=1.28U
* device instance $8 r0 *1 7.71,1.83 nfet
X$8 \$5__t3 \$136__t2 VSS__t207 VSS__t641 nfet_03v3 L=0.28U W=0.36U AS=0.169P
+ AD=0.1022P PS=1.28U PD=0.96U
* device instance $9 r0 *1 10.13,1.77 nfet
X$9 \$139__t3 WL0__t235 BL2__t0 VSS__t258 nfet_03v3 L=0.28U W=0.24U AS=0.1684P
+ AD=0.1022P PS=1.72U PD=0.96U
* device instance $10 r0 *1 13.03,1.77 nfet
X$10 BLB2__t0 WL0__t57 \$6__t4 VSS__t386 nfet_03v3 L=0.28U W=0.24U AS=0.1022P
+ AD=0.1684P PS=0.96U PD=1.72U
* device instance $11 r0 *1 10.99,1.83 nfet
X$11 VSS__t97 \$6__t2 \$139__t4 VSS__t514 nfet_03v3 L=0.28U W=0.36U AS=0.1022P
+ AD=0.169P PS=0.96U PD=1.28U
* device instance $12 r0 *1 12.17,1.83 nfet
X$12 \$6__t3 \$139__t2 VSS__t221 VSS__t642 nfet_03v3 L=0.28U W=0.36U AS=0.169P
+ AD=0.1022P PS=1.28U PD=0.96U
* device instance $13 r0 *1 14.59,1.77 nfet
X$13 \$142__t3 WL0__t154 BL3__t0 VSS__t259 nfet_03v3 L=0.28U W=0.24U AS=0.1684P
+ AD=0.1022P PS=1.72U PD=0.96U
* device instance $14 r0 *1 17.49,1.77 nfet
X$14 BLB3__t0 WL0__t42 \$7__t4 VSS__t387 nfet_03v3 L=0.28U W=0.24U AS=0.1022P
+ AD=0.1684P PS=0.96U PD=1.72U
* device instance $15 r0 *1 15.45,1.83 nfet
X$15 VSS__t100 \$7__t2 \$142__t4 VSS__t515 nfet_03v3 L=0.28U W=0.36U AS=0.1022P
+ AD=0.169P PS=0.96U PD=1.28U
* device instance $16 r0 *1 16.63,1.83 nfet
X$16 \$7__t3 \$142__t2 VSS__t212 VSS__t643 nfet_03v3 L=0.28U W=0.36U AS=0.169P
+ AD=0.1022P PS=1.28U PD=0.96U
* device instance $17 r0 *1 19.05,1.77 nfet
X$17 \$145__t3 WL0__t148 BL4__t0 VSS__t260 nfet_03v3 L=0.28U W=0.24U AS=0.1684P
+ AD=0.1022P PS=1.72U PD=0.96U
* device instance $18 r0 *1 21.95,1.77 nfet
X$18 BLB4__t0 WL0__t5 \$8__t4 VSS__t388 nfet_03v3 L=0.28U W=0.24U AS=0.1022P
+ AD=0.1684P PS=0.96U PD=1.72U
* device instance $19 r0 *1 19.91,1.83 nfet
X$19 VSS__t84 \$8__t2 \$145__t4 VSS__t516 nfet_03v3 L=0.28U W=0.36U AS=0.1022P
+ AD=0.169P PS=0.96U PD=1.28U
* device instance $20 r0 *1 21.09,1.83 nfet
X$20 \$8__t3 \$145__t2 VSS__t217 VSS__t644 nfet_03v3 L=0.28U W=0.36U AS=0.169P
+ AD=0.1022P PS=1.28U PD=0.96U
* device instance $21 r0 *1 23.51,1.77 nfet
X$21 \$148__t3 WL0__t137 BL5__t0 VSS__t261 nfet_03v3 L=0.28U W=0.24U AS=0.1684P
+ AD=0.1022P PS=1.72U PD=0.96U
* device instance $22 r0 *1 26.41,1.77 nfet
X$22 BLB5__t0 WL0__t8 \$9__t4 VSS__t389 nfet_03v3 L=0.28U W=0.24U AS=0.1022P
+ AD=0.1684P PS=0.96U PD=1.72U
* device instance $23 r0 *1 24.37,1.83 nfet
X$23 VSS__t113 \$9__t2 \$148__t4 VSS__t517 nfet_03v3 L=0.28U W=0.36U AS=0.1022P
+ AD=0.169P PS=0.96U PD=1.28U
* device instance $24 r0 *1 25.55,1.83 nfet
X$24 \$9__t3 \$148__t2 VSS__t247 VSS__t645 nfet_03v3 L=0.28U W=0.36U AS=0.169P
+ AD=0.1022P PS=1.28U PD=0.96U
* device instance $25 r0 *1 27.97,1.77 nfet
X$25 \$151__t3 WL0__t178 BL6__t0 VSS__t262 nfet_03v3 L=0.28U W=0.24U AS=0.1684P
+ AD=0.1022P PS=1.72U PD=0.96U
* device instance $26 r0 *1 30.87,1.77 nfet
X$26 BLB6__t0 WL0__t56 \$10__t4 VSS__t390 nfet_03v3 L=0.28U W=0.24U AS=0.1022P
+ AD=0.1684P PS=0.96U PD=1.72U
* device instance $27 r0 *1 28.83,1.83 nfet
X$27 VSS__t114 \$10__t2 \$151__t4 VSS__t518 nfet_03v3 L=0.28U W=0.36U
+ AS=0.1022P AD=0.169P PS=0.96U PD=1.28U
* device instance $28 r0 *1 30.01,1.83 nfet
X$28 \$10__t3 \$151__t2 VSS__t249 VSS__t646 nfet_03v3 L=0.28U W=0.36U AS=0.169P
+ AD=0.1022P PS=1.28U PD=0.96U
* device instance $29 r0 *1 32.43,1.77 nfet
X$29 \$154__t3 WL0__t158 BL7__t0 VSS__t263 nfet_03v3 L=0.28U W=0.24U AS=0.1684P
+ AD=0.1022P PS=1.72U PD=0.96U
* device instance $30 r0 *1 35.33,1.77 nfet
X$30 BLB7__t0 WL0__t46 \$11__t4 VSS__t391 nfet_03v3 L=0.28U W=0.24U AS=0.1022P
+ AD=0.1684P PS=0.96U PD=1.72U
* device instance $31 r0 *1 33.29,1.83 nfet
X$31 VSS__t37 \$11__t2 \$154__t4 VSS__t519 nfet_03v3 L=0.28U W=0.36U AS=0.1022P
+ AD=0.169P PS=0.96U PD=1.28U
* device instance $32 r0 *1 34.47,1.83 nfet
X$32 \$11__t3 \$154__t2 VSS__t255 VSS__t647 nfet_03v3 L=0.28U W=0.36U AS=0.169P
+ AD=0.1022P PS=1.28U PD=0.96U
* device instance $33 r0 *1 36.89,1.77 nfet
X$33 \$157__t3 WL0__t215 BL8__t0 VSS__t264 nfet_03v3 L=0.28U W=0.24U AS=0.1684P
+ AD=0.1022P PS=1.72U PD=0.96U
* device instance $34 r0 *1 39.79,1.77 nfet
X$34 BLB8__t0 WL0__t22 \$12__t4 VSS__t392 nfet_03v3 L=0.28U W=0.24U AS=0.1022P
+ AD=0.1684P PS=0.96U PD=1.72U
* device instance $35 r0 *1 37.75,1.83 nfet
X$35 VSS__t33 \$12__t2 \$157__t4 VSS__t520 nfet_03v3 L=0.28U W=0.36U AS=0.1022P
+ AD=0.169P PS=0.96U PD=1.28U
* device instance $36 r0 *1 38.93,1.83 nfet
X$36 \$12__t3 \$157__t2 VSS__t242 VSS__t648 nfet_03v3 L=0.28U W=0.36U AS=0.169P
+ AD=0.1022P PS=1.28U PD=0.96U
* device instance $37 r0 *1 41.35,1.77 nfet
X$37 \$160__t3 WL0__t219 BL9__t0 VSS__t265 nfet_03v3 L=0.28U W=0.24U AS=0.1684P
+ AD=0.1022P PS=1.72U PD=0.96U
* device instance $38 r0 *1 44.25,1.77 nfet
X$38 BLB9__t0 WL0__t25 \$13__t4 VSS__t393 nfet_03v3 L=0.28U W=0.24U AS=0.1022P
+ AD=0.1684P PS=0.96U PD=1.72U
* device instance $39 r0 *1 42.21,1.83 nfet
X$39 VSS__t29 \$13__t2 \$160__t4 VSS__t521 nfet_03v3 L=0.28U W=0.36U AS=0.1022P
+ AD=0.169P PS=0.96U PD=1.28U
* device instance $40 r0 *1 43.39,1.83 nfet
X$40 \$13__t3 \$160__t2 VSS__t243 VSS__t649 nfet_03v3 L=0.28U W=0.36U AS=0.169P
+ AD=0.1022P PS=1.28U PD=0.96U
* device instance $41 r0 *1 45.81,1.77 nfet
X$41 \$163__t3 WL0__t213 BL10__t0 VSS__t266 nfet_03v3 L=0.28U W=0.24U
+ AS=0.1684P AD=0.1022P PS=1.72U PD=0.96U
* device instance $42 r0 *1 48.71,1.77 nfet
X$42 BLB10__t0 WL0__t28 \$14__t4 VSS__t394 nfet_03v3 L=0.28U W=0.24U AS=0.1022P
+ AD=0.1684P PS=0.96U PD=1.72U
* device instance $43 r0 *1 46.67,1.83 nfet
X$43 VSS__t20 \$14__t2 \$163__t4 VSS__t522 nfet_03v3 L=0.28U W=0.36U AS=0.1022P
+ AD=0.169P PS=0.96U PD=1.28U
* device instance $44 r0 *1 47.85,1.83 nfet
X$44 \$14__t3 \$163__t2 VSS__t233 VSS__t650 nfet_03v3 L=0.28U W=0.36U AS=0.169P
+ AD=0.1022P PS=1.28U PD=0.96U
* device instance $45 r0 *1 50.27,1.77 nfet
X$45 \$166__t3 WL0__t202 BL11__t0 VSS__t267 nfet_03v3 L=0.28U W=0.24U
+ AS=0.1684P AD=0.1022P PS=1.72U PD=0.96U
* device instance $46 r0 *1 53.17,1.77 nfet
X$46 BLB11__t0 WL0__t38 \$15__t4 VSS__t395 nfet_03v3 L=0.28U W=0.24U AS=0.1022P
+ AD=0.1684P PS=0.96U PD=1.72U
* device instance $47 r0 *1 51.13,1.83 nfet
X$47 VSS__t109 \$15__t2 \$166__t4 VSS__t523 nfet_03v3 L=0.28U W=0.36U
+ AS=0.1022P AD=0.169P PS=0.96U PD=1.28U
* device instance $48 r0 *1 52.31,1.83 nfet
X$48 \$15__t3 \$166__t2 VSS__t200 VSS__t651 nfet_03v3 L=0.28U W=0.36U AS=0.169P
+ AD=0.1022P PS=1.28U PD=0.96U
* device instance $49 r0 *1 54.73,1.77 nfet
X$49 \$169__t3 WL0__t250 BL12__t0 VSS__t268 nfet_03v3 L=0.28U W=0.24U
+ AS=0.1684P AD=0.1022P PS=1.72U PD=0.96U
* device instance $50 r0 *1 57.63,1.77 nfet
X$50 BLB12__t0 WL0__t31 \$16__t4 VSS__t396 nfet_03v3 L=0.28U W=0.24U AS=0.1022P
+ AD=0.1684P PS=0.96U PD=1.72U
* device instance $51 r0 *1 55.59,1.83 nfet
X$51 VSS__t126 \$16__t2 \$169__t4 VSS__t524 nfet_03v3 L=0.28U W=0.36U
+ AS=0.1022P AD=0.169P PS=0.96U PD=1.28U
* device instance $52 r0 *1 56.77,1.83 nfet
X$52 \$16__t3 \$169__t2 VSS__t202 VSS__t652 nfet_03v3 L=0.28U W=0.36U AS=0.169P
+ AD=0.1022P PS=1.28U PD=0.96U
* device instance $53 r0 *1 59.19,1.77 nfet
X$53 \$172__t3 WL0__t253 BL13__t0 VSS__t269 nfet_03v3 L=0.28U W=0.24U
+ AS=0.1684P AD=0.1022P PS=1.72U PD=0.96U
* device instance $54 r0 *1 62.09,1.77 nfet
X$54 BLB13__t0 WL0__t24 \$17__t4 VSS__t397 nfet_03v3 L=0.28U W=0.24U AS=0.1022P
+ AD=0.1684P PS=0.96U PD=1.72U
* device instance $55 r0 *1 60.05,1.83 nfet
X$55 VSS__t125 \$17__t2 \$172__t4 VSS__t525 nfet_03v3 L=0.28U W=0.36U
+ AS=0.1022P AD=0.169P PS=0.96U PD=1.28U
* device instance $56 r0 *1 61.23,1.83 nfet
X$56 \$17__t3 \$172__t2 VSS__t203 VSS__t653 nfet_03v3 L=0.28U W=0.36U AS=0.169P
+ AD=0.1022P PS=1.28U PD=0.96U
* device instance $57 r0 *1 63.65,1.77 nfet
X$57 \$175__t3 WL0__t224 BL14__t0 VSS__t270 nfet_03v3 L=0.28U W=0.24U
+ AS=0.1684P AD=0.1022P PS=1.72U PD=0.96U
* device instance $58 r0 *1 66.55,1.77 nfet
X$58 BLB14__t0 WL0__t23 \$18__t4 VSS__t398 nfet_03v3 L=0.28U W=0.24U AS=0.1022P
+ AD=0.1684P PS=0.96U PD=1.72U
* device instance $59 r0 *1 64.51,1.83 nfet
X$59 VSS__t77 \$18__t2 \$175__t4 VSS__t526 nfet_03v3 L=0.28U W=0.36U AS=0.1022P
+ AD=0.169P PS=0.96U PD=1.28U
* device instance $60 r0 *1 65.69,1.83 nfet
X$60 \$18__t3 \$175__t2 VSS__t204 VSS__t654 nfet_03v3 L=0.28U W=0.36U AS=0.169P
+ AD=0.1022P PS=1.28U PD=0.96U
* device instance $61 r0 *1 68.11,1.77 nfet
X$61 \$178__t3 WL0__t227 BL15__t0 VSS__t271 nfet_03v3 L=0.28U W=0.24U
+ AS=0.1684P AD=0.1022P PS=1.72U PD=0.96U
* device instance $62 r0 *1 71.01,1.77 nfet
X$62 BLB15__t0 WL0__t21 \$19__t4 VSS__t399 nfet_03v3 L=0.28U W=0.24U AS=0.1022P
+ AD=0.1684P PS=0.96U PD=1.72U
* device instance $63 r0 *1 68.97,1.83 nfet
X$63 VSS__t116 \$19__t2 \$178__t4 VSS__t527 nfet_03v3 L=0.28U W=0.36U
+ AS=0.1022P AD=0.169P PS=0.96U PD=1.28U
* device instance $64 r0 *1 70.15,1.83 nfet
X$64 \$19__t3 \$178__t2 VSS__t206 VSS__t655 nfet_03v3 L=0.28U W=0.36U AS=0.169P
+ AD=0.1022P PS=1.28U PD=0.96U
* device instance $65 r0 *1 72.57,1.77 nfet
X$65 \$181__t3 WL0__t140 BL16__t0 VSS__t272 nfet_03v3 L=0.28U W=0.24U
+ AS=0.1684P AD=0.1022P PS=1.72U PD=0.96U
* device instance $66 r0 *1 75.47,1.77 nfet
X$66 BLB16__t0 WL0__t112 \$20__t4 VSS__t400 nfet_03v3 L=0.28U W=0.24U
+ AS=0.1022P AD=0.1684P PS=0.96U PD=1.72U
* device instance $67 r0 *1 73.43,1.83 nfet
X$67 VSS__t40 \$20__t2 \$181__t4 VSS__t528 nfet_03v3 L=0.28U W=0.36U AS=0.1022P
+ AD=0.169P PS=0.96U PD=1.28U
* device instance $68 r0 *1 74.61,1.83 nfet
X$68 \$20__t3 \$181__t2 VSS__t229 VSS__t656 nfet_03v3 L=0.28U W=0.36U AS=0.169P
+ AD=0.1022P PS=1.28U PD=0.96U
* device instance $69 r0 *1 77.03,1.77 nfet
X$69 \$184__t3 WL0__t133 BL17__t0 VSS__t273 nfet_03v3 L=0.28U W=0.24U
+ AS=0.1684P AD=0.1022P PS=1.72U PD=0.96U
* device instance $70 r0 *1 79.93,1.77 nfet
X$70 BLB17__t0 WL0__t111 \$21__t4 VSS__t401 nfet_03v3 L=0.28U W=0.24U
+ AS=0.1022P AD=0.1684P PS=0.96U PD=1.72U
* device instance $71 r0 *1 77.89,1.83 nfet
X$71 VSS__t43 \$21__t2 \$184__t4 VSS__t529 nfet_03v3 L=0.28U W=0.36U AS=0.1022P
+ AD=0.169P PS=0.96U PD=1.28U
* device instance $72 r0 *1 79.07,1.83 nfet
X$72 \$21__t3 \$184__t2 VSS__t228 VSS__t657 nfet_03v3 L=0.28U W=0.36U AS=0.169P
+ AD=0.1022P PS=1.28U PD=0.96U
* device instance $73 r0 *1 81.49,1.77 nfet
X$73 \$187__t3 WL0__t162 BL18__t0 VSS__t274 nfet_03v3 L=0.28U W=0.24U
+ AS=0.1684P AD=0.1022P PS=1.72U PD=0.96U
* device instance $74 r0 *1 84.39,1.77 nfet
X$74 BLB18__t0 WL0__t114 \$22__t4 VSS__t402 nfet_03v3 L=0.28U W=0.24U
+ AS=0.1022P AD=0.1684P PS=0.96U PD=1.72U
* device instance $75 r0 *1 82.35,1.83 nfet
X$75 VSS__t44 \$22__t2 \$187__t4 VSS__t530 nfet_03v3 L=0.28U W=0.36U AS=0.1022P
+ AD=0.169P PS=0.96U PD=1.28U
* device instance $76 r0 *1 83.53,1.83 nfet
X$76 \$22__t3 \$187__t2 VSS__t227 VSS__t658 nfet_03v3 L=0.28U W=0.36U AS=0.169P
+ AD=0.1022P PS=1.28U PD=0.96U
* device instance $77 r0 *1 85.95,1.77 nfet
X$77 \$190__t3 WL0__t182 BL19__t0 VSS__t275 nfet_03v3 L=0.28U W=0.24U
+ AS=0.1684P AD=0.1022P PS=1.72U PD=0.96U
* device instance $78 r0 *1 88.85,1.77 nfet
X$78 BLB19__t0 WL0__t117 \$23__t4 VSS__t403 nfet_03v3 L=0.28U W=0.24U
+ AS=0.1022P AD=0.1684P PS=0.96U PD=1.72U
* device instance $79 r0 *1 86.81,1.83 nfet
X$79 VSS__t47 \$23__t2 \$190__t4 VSS__t531 nfet_03v3 L=0.28U W=0.36U AS=0.1022P
+ AD=0.169P PS=0.96U PD=1.28U
* device instance $80 r0 *1 87.99,1.83 nfet
X$80 \$23__t3 \$190__t2 VSS__t225 VSS__t659 nfet_03v3 L=0.28U W=0.36U AS=0.169P
+ AD=0.1022P PS=1.28U PD=0.96U
* device instance $81 r0 *1 90.41,1.77 nfet
X$81 \$193__t3 WL0__t156 BL20__t0 VSS__t276 nfet_03v3 L=0.28U W=0.24U
+ AS=0.1684P AD=0.1022P PS=1.72U PD=0.96U
* device instance $82 r0 *1 93.31,1.77 nfet
X$82 BLB20__t0 WL0__t120 \$24__t4 VSS__t404 nfet_03v3 L=0.28U W=0.24U
+ AS=0.1022P AD=0.1684P PS=0.96U PD=1.72U
* device instance $83 r0 *1 91.27,1.83 nfet
X$83 VSS__t50 \$24__t2 \$193__t4 VSS__t532 nfet_03v3 L=0.28U W=0.36U AS=0.1022P
+ AD=0.169P PS=0.96U PD=1.28U
* device instance $84 r0 *1 92.45,1.83 nfet
X$84 \$24__t3 \$193__t2 VSS__t224 VSS__t660 nfet_03v3 L=0.28U W=0.36U AS=0.169P
+ AD=0.1022P PS=1.28U PD=0.96U
* device instance $85 r0 *1 94.87,1.77 nfet
X$85 \$196__t3 WL0__t165 BL21__t0 VSS__t277 nfet_03v3 L=0.28U W=0.24U
+ AS=0.1684P AD=0.1022P PS=1.72U PD=0.96U
* device instance $86 r0 *1 97.77,1.77 nfet
X$86 BLB21__t0 WL0__t127 \$25__t4 VSS__t405 nfet_03v3 L=0.28U W=0.24U
+ AS=0.1022P AD=0.1684P PS=0.96U PD=1.72U
* device instance $87 r0 *1 95.73,1.83 nfet
X$87 VSS__t54 \$25__t2 \$196__t4 VSS__t533 nfet_03v3 L=0.28U W=0.36U AS=0.1022P
+ AD=0.169P PS=0.96U PD=1.28U
* device instance $88 r0 *1 96.91,1.83 nfet
X$88 \$25__t3 \$196__t2 VSS__t222 VSS__t661 nfet_03v3 L=0.28U W=0.36U AS=0.169P
+ AD=0.1022P PS=1.28U PD=0.96U
* device instance $89 r0 *1 99.33,1.77 nfet
X$89 \$199__t3 WL0__t170 BL22__t0 VSS__t278 nfet_03v3 L=0.28U W=0.24U
+ AS=0.1684P AD=0.1022P PS=1.72U PD=0.96U
* device instance $90 r0 *1 102.23,1.77 nfet
X$90 BLB22__t0 WL0__t29 \$26__t4 VSS__t406 nfet_03v3 L=0.28U W=0.24U AS=0.1022P
+ AD=0.1684P PS=0.96U PD=1.72U
* device instance $91 r0 *1 100.19,1.83 nfet
X$91 VSS__t53 \$26__t2 \$199__t4 VSS__t534 nfet_03v3 L=0.28U W=0.36U AS=0.1022P
+ AD=0.169P PS=0.96U PD=1.28U
* device instance $92 r0 *1 101.37,1.83 nfet
X$92 \$26__t3 \$199__t2 VSS__t223 VSS__t662 nfet_03v3 L=0.28U W=0.36U AS=0.169P
+ AD=0.1022P PS=1.28U PD=0.96U
* device instance $93 r0 *1 103.79,1.77 nfet
X$93 \$202__t3 WL0__t161 BL23__t0 VSS__t279 nfet_03v3 L=0.28U W=0.24U
+ AS=0.1684P AD=0.1022P PS=1.72U PD=0.96U
* device instance $94 r0 *1 106.69,1.77 nfet
X$94 BLB23__t0 WL0__t15 \$27__t4 VSS__t407 nfet_03v3 L=0.28U W=0.24U AS=0.1022P
+ AD=0.1684P PS=0.96U PD=1.72U
* device instance $95 r0 *1 104.65,1.83 nfet
X$95 VSS__t49 \$27__t2 \$202__t4 VSS__t535 nfet_03v3 L=0.28U W=0.36U AS=0.1022P
+ AD=0.169P PS=0.96U PD=1.28U
* device instance $96 r0 *1 105.83,1.83 nfet
X$96 \$27__t3 \$202__t2 VSS__t226 VSS__t663 nfet_03v3 L=0.28U W=0.36U AS=0.169P
+ AD=0.1022P PS=1.28U PD=0.96U
* device instance $97 r0 *1 108.25,1.77 nfet
X$97 \$205__t3 WL0__t186 BL24__t0 VSS__t280 nfet_03v3 L=0.28U W=0.24U
+ AS=0.1684P AD=0.1022P PS=1.72U PD=0.96U
* device instance $98 r0 *1 111.15,1.77 nfet
X$98 BLB24__t0 WL0__t9 \$28__t4 VSS__t408 nfet_03v3 L=0.28U W=0.24U AS=0.1022P
+ AD=0.1684P PS=0.96U PD=1.72U
* device instance $99 r0 *1 109.11,1.83 nfet
X$99 VSS__t39 \$28__t2 \$205__t4 VSS__t536 nfet_03v3 L=0.28U W=0.36U AS=0.1022P
+ AD=0.169P PS=0.96U PD=1.28U
* device instance $100 r0 *1 110.29,1.83 nfet
X$100 \$28__t3 \$205__t2 VSS__t230 VSS__t664 nfet_03v3 L=0.28U W=0.36U
+ AS=0.169P AD=0.1022P PS=1.28U PD=0.96U
* device instance $101 r0 *1 112.71,1.77 nfet
X$101 \$208__t3 WL0__t237 BL25__t0 VSS__t281 nfet_03v3 L=0.28U W=0.24U
+ AS=0.1684P AD=0.1022P PS=1.72U PD=0.96U
* device instance $102 r0 *1 115.61,1.77 nfet
X$102 BLB25__t0 WL0__t6 \$29__t4 VSS__t409 nfet_03v3 L=0.28U W=0.24U AS=0.1022P
+ AD=0.1684P PS=0.96U PD=1.72U
* device instance $103 r0 *1 113.57,1.83 nfet
X$103 VSS__t67 \$29__t2 \$208__t4 VSS__t537 nfet_03v3 L=0.28U W=0.36U
+ AS=0.1022P AD=0.169P PS=0.96U PD=1.28U
* device instance $104 r0 *1 114.75,1.83 nfet
X$104 \$29__t3 \$208__t2 VSS__t245 VSS__t665 nfet_03v3 L=0.28U W=0.36U
+ AS=0.169P AD=0.1022P PS=1.28U PD=0.96U
* device instance $105 r0 *1 117.17,1.77 nfet
X$105 \$211__t3 WL0__t199 BL26__t0 VSS__t282 nfet_03v3 L=0.28U W=0.24U
+ AS=0.1684P AD=0.1022P PS=1.72U PD=0.96U
* device instance $106 r0 *1 120.07,1.77 nfet
X$106 BLB26__t0 WL0__t45 \$30__t4 VSS__t410 nfet_03v3 L=0.28U W=0.24U
+ AS=0.1022P AD=0.1684P PS=0.96U PD=1.72U
* device instance $107 r0 *1 118.03,1.83 nfet
X$107 VSS__t58 \$30__t2 \$211__t4 VSS__t538 nfet_03v3 L=0.28U W=0.36U
+ AS=0.1022P AD=0.169P PS=0.96U PD=1.28U
* device instance $108 r0 *1 119.21,1.83 nfet
X$108 \$30__t3 \$211__t2 VSS__t234 VSS__t666 nfet_03v3 L=0.28U W=0.36U
+ AS=0.169P AD=0.1022P PS=1.28U PD=0.96U
* device instance $109 r0 *1 121.63,1.77 nfet
X$109 \$214__t3 WL0__t192 BL27__t0 VSS__t283 nfet_03v3 L=0.28U W=0.24U
+ AS=0.1684P AD=0.1022P PS=1.72U PD=0.96U
* device instance $110 r0 *1 124.53,1.77 nfet
X$110 BLB27__t0 WL0__t47 \$31__t4 VSS__t411 nfet_03v3 L=0.28U W=0.24U
+ AS=0.1022P AD=0.1684P PS=0.96U PD=1.72U
* device instance $111 r0 *1 122.49,1.83 nfet
X$111 VSS__t56 \$31__t2 \$214__t4 VSS__t539 nfet_03v3 L=0.28U W=0.36U
+ AS=0.1022P AD=0.169P PS=0.96U PD=1.28U
* device instance $112 r0 *1 123.67,1.83 nfet
X$112 \$31__t3 \$214__t2 VSS__t235 VSS__t667 nfet_03v3 L=0.28U W=0.36U
+ AS=0.169P AD=0.1022P PS=1.28U PD=0.96U
* device instance $113 r0 *1 126.09,1.77 nfet
X$113 \$217__t3 WL0__t216 BL28__t0 VSS__t284 nfet_03v3 L=0.28U W=0.24U
+ AS=0.1684P AD=0.1022P PS=1.72U PD=0.96U
* device instance $114 r0 *1 128.99,1.77 nfet
X$114 BLB28__t0 WL0__t50 \$32__t4 VSS__t412 nfet_03v3 L=0.28U W=0.24U
+ AS=0.1022P AD=0.1684P PS=0.96U PD=1.72U
* device instance $115 r0 *1 126.95,1.83 nfet
X$115 VSS__t14 \$32__t2 \$217__t4 VSS__t540 nfet_03v3 L=0.28U W=0.36U
+ AS=0.1022P AD=0.169P PS=0.96U PD=1.28U
* device instance $116 r0 *1 128.13,1.83 nfet
X$116 \$32__t3 \$217__t2 VSS__t237 VSS__t668 nfet_03v3 L=0.28U W=0.36U
+ AS=0.169P AD=0.1022P PS=1.28U PD=0.96U
* device instance $117 r0 *1 130.55,1.77 nfet
X$117 \$220__t3 WL0__t207 BL29__t0 VSS__t285 nfet_03v3 L=0.28U W=0.24U
+ AS=0.1684P AD=0.1022P PS=1.72U PD=0.96U
* device instance $118 r0 *1 133.45,1.77 nfet
X$118 BLB29__t0 WL0__t52 \$33__t4 VSS__t413 nfet_03v3 L=0.28U W=0.24U
+ AS=0.1022P AD=0.1684P PS=0.96U PD=1.72U
* device instance $119 r0 *1 131.41,1.83 nfet
X$119 VSS__t10 \$33__t2 \$220__t4 VSS__t541 nfet_03v3 L=0.28U W=0.36U
+ AS=0.1022P AD=0.169P PS=0.96U PD=1.28U
* device instance $120 r0 *1 132.59,1.83 nfet
X$120 \$33__t3 \$220__t2 VSS__t238 VSS__t669 nfet_03v3 L=0.28U W=0.36U
+ AS=0.169P AD=0.1022P PS=1.28U PD=0.96U
* device instance $121 r0 *1 135.01,1.77 nfet
X$121 \$223__t3 WL0__t208 BL30__t0 VSS__t286 nfet_03v3 L=0.28U W=0.24U
+ AS=0.1684P AD=0.1022P PS=1.72U PD=0.96U
* device instance $122 r0 *1 137.91,1.77 nfet
X$122 BLB30__t0 WL0__t54 \$34__t4 VSS__t414 nfet_03v3 L=0.28U W=0.24U
+ AS=0.1022P AD=0.1684P PS=0.96U PD=1.72U
* device instance $123 r0 *1 135.87,1.83 nfet
X$123 VSS__t17 \$34__t2 \$223__t4 VSS__t542 nfet_03v3 L=0.28U W=0.36U
+ AS=0.1022P AD=0.169P PS=0.96U PD=1.28U
* device instance $124 r0 *1 137.05,1.83 nfet
X$124 \$34__t3 \$223__t2 VSS__t239 VSS__t670 nfet_03v3 L=0.28U W=0.36U
+ AS=0.169P AD=0.1022P PS=1.28U PD=0.96U
* device instance $125 r0 *1 139.47,1.77 nfet
X$125 \$226__t3 WL0__t212 BL31__t0 VSS__t287 nfet_03v3 L=0.28U W=0.24U
+ AS=0.1684P AD=0.1022P PS=1.72U PD=0.96U
* device instance $126 r0 *1 142.37,1.77 nfet
X$126 BLB31__t0 WL0__t48 \$35__t4 VSS__t415 nfet_03v3 L=0.28U W=0.24U
+ AS=0.1022P AD=0.1684P PS=0.96U PD=1.72U
* device instance $127 r0 *1 140.33,1.83 nfet
X$127 VSS__t6 \$35__t2 \$226__t4 VSS__t543 nfet_03v3 L=0.28U W=0.36U AS=0.1022P
+ AD=0.169P PS=0.96U PD=1.28U
* device instance $128 r0 *1 141.51,1.83 nfet
X$128 \$35__t3 \$226__t2 VSS__t241 VSS__t671 nfet_03v3 L=0.28U W=0.36U
+ AS=0.169P AD=0.1022P PS=1.28U PD=0.96U
* device instance $129 r0 *1 143.93,1.77 nfet
X$129 \$229__t3 WL0__t139 BL32__t0 VSS__t288 nfet_03v3 L=0.28U W=0.24U
+ AS=0.1684P AD=0.1022P PS=1.72U PD=0.96U
* device instance $130 r0 *1 146.83,1.77 nfet
X$130 BLB32__t0 WL0__t100 \$36__t4 VSS__t416 nfet_03v3 L=0.28U W=0.24U
+ AS=0.1022P AD=0.1684P PS=0.96U PD=1.72U
* device instance $131 r0 *1 144.79,1.83 nfet
X$131 VSS__t128 \$36__t2 \$229__t4 VSS__t544 nfet_03v3 L=0.28U W=0.36U
+ AS=0.1022P AD=0.169P PS=0.96U PD=1.28U
* device instance $132 r0 *1 145.97,1.83 nfet
X$132 \$36__t3 \$229__t2 VSS__t218 VSS__t672 nfet_03v3 L=0.28U W=0.36U
+ AS=0.169P AD=0.1022P PS=1.28U PD=0.96U
* device instance $133 r0 *1 148.39,1.77 nfet
X$133 \$232__t3 WL0__t141 BL33__t0 VSS__t289 nfet_03v3 L=0.28U W=0.24U
+ AS=0.1684P AD=0.1022P PS=1.72U PD=0.96U
* device instance $134 r0 *1 151.29,1.77 nfet
X$134 BLB33__t0 WL0__t101 \$37__t4 VSS__t417 nfet_03v3 L=0.28U W=0.24U
+ AS=0.1022P AD=0.1684P PS=0.96U PD=1.72U
* device instance $135 r0 *1 149.25,1.83 nfet
X$135 VSS__t82 \$37__t2 \$232__t4 VSS__t545 nfet_03v3 L=0.28U W=0.36U
+ AS=0.1022P AD=0.169P PS=0.96U PD=1.28U
* device instance $136 r0 *1 150.43,1.83 nfet
X$136 \$37__t3 \$232__t2 VSS__t216 VSS__t673 nfet_03v3 L=0.28U W=0.36U
+ AS=0.169P AD=0.1022P PS=1.28U PD=0.96U
* device instance $137 r0 *1 152.85,1.77 nfet
X$137 \$235__t3 WL0__t144 BL34__t0 VSS__t290 nfet_03v3 L=0.28U W=0.24U
+ AS=0.1684P AD=0.1022P PS=1.72U PD=0.96U
* device instance $138 r0 *1 155.75,1.77 nfet
X$138 BLB34__t0 WL0__t102 \$38__t4 VSS__t418 nfet_03v3 L=0.28U W=0.24U
+ AS=0.1022P AD=0.1684P PS=0.96U PD=1.72U
* device instance $139 r0 *1 153.71,1.83 nfet
X$139 VSS__t104 \$38__t2 \$235__t4 VSS__t546 nfet_03v3 L=0.28U W=0.36U
+ AS=0.1022P AD=0.169P PS=0.96U PD=1.28U
* device instance $140 r0 *1 154.89,1.83 nfet
X$140 \$38__t3 \$235__t2 VSS__t215 VSS__t674 nfet_03v3 L=0.28U W=0.36U
+ AS=0.169P AD=0.1022P PS=1.28U PD=0.96U
* device instance $141 r0 *1 157.31,1.77 nfet
X$141 \$238__t3 WL0__t149 BL35__t0 VSS__t291 nfet_03v3 L=0.28U W=0.24U
+ AS=0.1684P AD=0.1022P PS=1.72U PD=0.96U
* device instance $142 r0 *1 160.21,1.77 nfet
X$142 BLB35__t0 WL0__t103 \$39__t4 VSS__t419 nfet_03v3 L=0.28U W=0.24U
+ AS=0.1022P AD=0.1684P PS=0.96U PD=1.72U
* device instance $143 r0 *1 158.17,1.83 nfet
X$143 VSS__t93 \$39__t2 \$238__t4 VSS__t547 nfet_03v3 L=0.28U W=0.36U
+ AS=0.1022P AD=0.169P PS=0.96U PD=1.28U
* device instance $144 r0 *1 159.35,1.83 nfet
X$144 \$39__t3 \$238__t2 VSS__t214 VSS__t675 nfet_03v3 L=0.28U W=0.36U
+ AS=0.169P AD=0.1022P PS=1.28U PD=0.96U
* device instance $145 r0 *1 161.77,1.77 nfet
X$145 \$241__t3 WL0__t151 BL36__t0 VSS__t292 nfet_03v3 L=0.28U W=0.24U
+ AS=0.1684P AD=0.1022P PS=1.72U PD=0.96U
* device instance $146 r0 *1 164.67,1.77 nfet
X$146 BLB36__t0 WL0__t104 \$40__t4 VSS__t420 nfet_03v3 L=0.28U W=0.24U
+ AS=0.1022P AD=0.1684P PS=0.96U PD=1.72U
* device instance $147 r0 *1 162.63,1.83 nfet
X$147 VSS__t80 \$40__t2 \$241__t4 VSS__t548 nfet_03v3 L=0.28U W=0.36U
+ AS=0.1022P AD=0.169P PS=0.96U PD=1.28U
* device instance $148 r0 *1 163.81,1.83 nfet
X$148 \$40__t3 \$241__t2 VSS__t213 VSS__t676 nfet_03v3 L=0.28U W=0.36U
+ AS=0.169P AD=0.1022P PS=1.28U PD=0.96U
* device instance $149 r0 *1 166.23,1.77 nfet
X$149 \$244__t3 WL0__t150 BL37__t0 VSS__t293 nfet_03v3 L=0.28U W=0.24U
+ AS=0.1684P AD=0.1022P PS=1.72U PD=0.96U
* device instance $150 r0 *1 169.13,1.77 nfet
X$150 BLB37__t0 WL0__t105 \$41__t4 VSS__t421 nfet_03v3 L=0.28U W=0.24U
+ AS=0.1022P AD=0.1684P PS=0.96U PD=1.72U
* device instance $151 r0 *1 167.09,1.83 nfet
X$151 VSS__t101 \$41__t2 \$244__t4 VSS__t549 nfet_03v3 L=0.28U W=0.36U
+ AS=0.1022P AD=0.169P PS=0.96U PD=1.28U
* device instance $152 r0 *1 168.27,1.83 nfet
X$152 \$41__t3 \$244__t2 VSS__t211 VSS__t677 nfet_03v3 L=0.28U W=0.36U
+ AS=0.169P AD=0.1022P PS=1.28U PD=0.96U
* device instance $153 r0 *1 170.69,1.77 nfet
X$153 \$247__t3 WL0__t135 BL38__t0 VSS__t294 nfet_03v3 L=0.28U W=0.24U
+ AS=0.1684P AD=0.1022P PS=1.72U PD=0.96U
* device instance $154 r0 *1 173.59,1.77 nfet
X$154 BLB38__t0 WL0__t106 \$42__t4 VSS__t422 nfet_03v3 L=0.28U W=0.24U
+ AS=0.1022P AD=0.1684P PS=0.96U PD=1.72U
* device instance $155 r0 *1 171.55,1.83 nfet
X$155 VSS__t99 \$42__t2 \$247__t4 VSS__t550 nfet_03v3 L=0.28U W=0.36U
+ AS=0.1022P AD=0.169P PS=0.96U PD=1.28U
* device instance $156 r0 *1 172.73,1.83 nfet
X$156 \$42__t3 \$247__t2 VSS__t210 VSS__t678 nfet_03v3 L=0.28U W=0.36U
+ AS=0.169P AD=0.1022P PS=1.28U PD=0.96U
* device instance $157 r0 *1 175.15,1.77 nfet
X$157 \$250__t3 WL0__t174 BL39__t0 VSS__t295 nfet_03v3 L=0.28U W=0.24U
+ AS=0.1684P AD=0.1022P PS=1.72U PD=0.96U
* device instance $158 r0 *1 178.05,1.77 nfet
X$158 BLB39__t0 WL0__t107 \$43__t4 VSS__t423 nfet_03v3 L=0.28U W=0.24U
+ AS=0.1022P AD=0.1684P PS=0.96U PD=1.72U
* device instance $159 r0 *1 176.01,1.83 nfet
X$159 VSS__t95 \$43__t2 \$250__t4 VSS__t551 nfet_03v3 L=0.28U W=0.36U
+ AS=0.1022P AD=0.169P PS=0.96U PD=1.28U
* device instance $160 r0 *1 177.19,1.83 nfet
X$160 \$43__t3 \$250__t2 VSS__t208 VSS__t679 nfet_03v3 L=0.28U W=0.36U
+ AS=0.169P AD=0.1022P PS=1.28U PD=0.96U
* device instance $161 r0 *1 179.61,1.77 nfet
X$161 \$253__t3 WL0__t236 BL40__t0 VSS__t296 nfet_03v3 L=0.28U W=0.24U
+ AS=0.1684P AD=0.1022P PS=1.72U PD=0.96U
* device instance $162 r0 *1 182.51,1.77 nfet
X$162 BLB40__t0 WL0__t96 \$44__t4 VSS__t424 nfet_03v3 L=0.28U W=0.24U
+ AS=0.1022P AD=0.1684P PS=0.96U PD=1.72U
* device instance $163 r0 *1 180.47,1.83 nfet
X$163 VSS__t86 \$44__t2 \$253__t4 VSS__t552 nfet_03v3 L=0.28U W=0.36U
+ AS=0.1022P AD=0.169P PS=0.96U PD=1.28U
* device instance $164 r0 *1 181.65,1.83 nfet
X$164 \$44__t3 \$253__t2 VSS__t205 VSS__t680 nfet_03v3 L=0.28U W=0.36U
+ AS=0.169P AD=0.1022P PS=1.28U PD=0.96U
* device instance $165 r0 *1 184.07,1.77 nfet
X$165 \$256__t3 WL0__t226 BL41__t0 VSS__t297 nfet_03v3 L=0.28U W=0.24U
+ AS=0.1684P AD=0.1022P PS=1.72U PD=0.96U
* device instance $166 r0 *1 186.97,1.77 nfet
X$166 BLB41__t0 WL0__t62 \$45__t4 VSS__t425 nfet_03v3 L=0.28U W=0.24U
+ AS=0.1022P AD=0.1684P PS=0.96U PD=1.72U
* device instance $167 r0 *1 184.93,1.83 nfet
X$167 VSS__t120 \$45__t2 \$256__t4 VSS__t553 nfet_03v3 L=0.28U W=0.36U
+ AS=0.1022P AD=0.169P PS=0.96U PD=1.28U
* device instance $168 r0 *1 186.11,1.83 nfet
X$168 \$45__t3 \$256__t2 VSS__t201 VSS__t681 nfet_03v3 L=0.28U W=0.36U
+ AS=0.169P AD=0.1022P PS=1.28U PD=0.96U
* device instance $169 r0 *1 188.53,1.77 nfet
X$169 \$259__t3 WL0__t247 BL42__t0 VSS__t298 nfet_03v3 L=0.28U W=0.24U
+ AS=0.1684P AD=0.1022P PS=1.72U PD=0.96U
* device instance $170 r0 *1 191.43,1.77 nfet
X$170 BLB42__t0 WL0__t67 \$46__t4 VSS__t426 nfet_03v3 L=0.28U W=0.24U
+ AS=0.1022P AD=0.1684P PS=0.96U PD=1.72U
* device instance $171 r0 *1 189.39,1.83 nfet
X$171 VSS__t107 \$46__t2 \$259__t4 VSS__t554 nfet_03v3 L=0.28U W=0.36U
+ AS=0.1022P AD=0.169P PS=0.96U PD=1.28U
* device instance $172 r0 *1 190.57,1.83 nfet
X$172 \$46__t3 \$259__t2 VSS__t199 VSS__t682 nfet_03v3 L=0.28U W=0.36U
+ AS=0.169P AD=0.1022P PS=1.28U PD=0.96U
* device instance $173 r0 *1 192.99,1.77 nfet
X$173 \$262__t3 WL0__t200 BL43__t0 VSS__t299 nfet_03v3 L=0.28U W=0.24U
+ AS=0.1684P AD=0.1022P PS=1.72U PD=0.96U
* device instance $174 r0 *1 195.89,1.77 nfet
X$174 BLB43__t0 WL0__t72 \$47__t4 VSS__t427 nfet_03v3 L=0.28U W=0.24U
+ AS=0.1022P AD=0.1684P PS=0.96U PD=1.72U
* device instance $175 r0 *1 193.85,1.83 nfet
X$175 VSS__t21 \$47__t2 \$262__t4 VSS__t555 nfet_03v3 L=0.28U W=0.36U
+ AS=0.1022P AD=0.169P PS=0.96U PD=1.28U
* device instance $176 r0 *1 195.03,1.83 nfet
X$176 \$47__t3 \$262__t2 VSS__t244 VSS__t683 nfet_03v3 L=0.28U W=0.36U
+ AS=0.169P AD=0.1022P PS=1.28U PD=0.96U
* device instance $177 r0 *1 197.45,1.77 nfet
X$177 \$265__t3 WL0__t189 BL44__t0 VSS__t300 nfet_03v3 L=0.28U W=0.24U
+ AS=0.1684P AD=0.1022P PS=1.72U PD=0.96U
* device instance $178 r0 *1 200.35,1.77 nfet
X$178 BLB44__t0 WL0__t77 \$48__t4 VSS__t428 nfet_03v3 L=0.28U W=0.24U
+ AS=0.1022P AD=0.1684P PS=0.96U PD=1.72U
* device instance $179 r0 *1 198.31,1.83 nfet
X$179 VSS__t34 \$48__t2 \$265__t4 VSS__t556 nfet_03v3 L=0.28U W=0.36U
+ AS=0.1022P AD=0.169P PS=0.96U PD=1.28U
* device instance $180 r0 *1 199.49,1.83 nfet
X$180 \$48__t3 \$265__t2 VSS__t240 VSS__t684 nfet_03v3 L=0.28U W=0.36U
+ AS=0.169P AD=0.1022P PS=1.28U PD=0.96U
* device instance $181 r0 *1 201.91,1.77 nfet
X$181 \$268__t3 WL0__t211 BL45__t0 VSS__t301 nfet_03v3 L=0.28U W=0.24U
+ AS=0.1684P AD=0.1022P PS=1.72U PD=0.96U
* device instance $182 r0 *1 204.81,1.77 nfet
X$182 BLB45__t0 WL0__t82 \$49__t4 VSS__t429 nfet_03v3 L=0.28U W=0.24U
+ AS=0.1022P AD=0.1684P PS=0.96U PD=1.72U
* device instance $183 r0 *1 202.77,1.83 nfet
X$183 VSS__t11 \$49__t2 \$268__t4 VSS__t557 nfet_03v3 L=0.28U W=0.36U
+ AS=0.1022P AD=0.169P PS=0.96U PD=1.28U
* device instance $184 r0 *1 203.95,1.83 nfet
X$184 \$49__t3 \$268__t2 VSS__t236 VSS__t685 nfet_03v3 L=0.28U W=0.36U
+ AS=0.169P AD=0.1022P PS=1.28U PD=0.96U
* device instance $185 r0 *1 206.37,1.77 nfet
X$185 \$271__t3 WL0__t220 BL46__t0 VSS__t302 nfet_03v3 L=0.28U W=0.24U
+ AS=0.1684P AD=0.1022P PS=1.72U PD=0.96U
* device instance $186 r0 *1 209.27,1.77 nfet
X$186 BLB46__t0 WL0__t116 \$50__t4 VSS__t430 nfet_03v3 L=0.28U W=0.24U
+ AS=0.1022P AD=0.1684P PS=0.96U PD=1.72U
* device instance $187 r0 *1 207.23,1.83 nfet
X$187 VSS__t60 \$50__t2 \$271__t4 VSS__t558 nfet_03v3 L=0.28U W=0.36U
+ AS=0.1022P AD=0.169P PS=0.96U PD=1.28U
* device instance $188 r0 *1 208.41,1.83 nfet
X$188 \$50__t3 \$271__t2 VSS__t232 VSS__t686 nfet_03v3 L=0.28U W=0.36U
+ AS=0.169P AD=0.1022P PS=1.28U PD=0.96U
* device instance $189 r0 *1 210.83,1.77 nfet
X$189 \$274__t3 WL0__t246 BL47__t0 VSS__t303 nfet_03v3 L=0.28U W=0.24U
+ AS=0.1684P AD=0.1022P PS=1.72U PD=0.96U
* device instance $190 r0 *1 213.73,1.77 nfet
X$190 BLB47__t0 WL0__t121 \$51__t4 VSS__t431 nfet_03v3 L=0.28U W=0.24U
+ AS=0.1022P AD=0.1684P PS=0.96U PD=1.72U
* device instance $191 r0 *1 211.69,1.83 nfet
X$191 VSS__t72 \$51__t2 \$274__t4 VSS__t559 nfet_03v3 L=0.28U W=0.36U
+ AS=0.1022P AD=0.169P PS=0.96U PD=1.28U
* device instance $192 r0 *1 212.87,1.83 nfet
X$192 \$51__t3 \$274__t2 VSS__t231 VSS__t687 nfet_03v3 L=0.28U W=0.36U
+ AS=0.169P AD=0.1022P PS=1.28U PD=0.96U
* device instance $193 r0 *1 215.29,1.77 nfet
X$193 \$277__t3 WL0__t185 BL48__t0 VSS__t304 nfet_03v3 L=0.28U W=0.24U
+ AS=0.1684P AD=0.1022P PS=1.72U PD=0.96U
* device instance $194 r0 *1 218.19,1.77 nfet
X$194 BLB48__t0 WL0__t91 \$52__t4 VSS__t432 nfet_03v3 L=0.28U W=0.24U
+ AS=0.1022P AD=0.1684P PS=0.96U PD=1.72U
* device instance $195 r0 *1 216.15,1.83 nfet
X$195 VSS__t23 \$52__t2 \$277__t4 VSS__t560 nfet_03v3 L=0.28U W=0.36U
+ AS=0.1022P AD=0.169P PS=0.96U PD=1.28U
* device instance $196 r0 *1 217.33,1.83 nfet
X$196 \$52__t3 \$277__t2 VSS__t129 VSS__t688 nfet_03v3 L=0.28U W=0.36U
+ AS=0.169P AD=0.1022P PS=1.28U PD=0.96U
* device instance $197 r0 *1 219.75,1.77 nfet
X$197 \$280__t3 WL0__t187 BL49__t0 VSS__t305 nfet_03v3 L=0.28U W=0.24U
+ AS=0.1684P AD=0.1022P PS=1.72U PD=0.96U
* device instance $198 r0 *1 222.65,1.77 nfet
X$198 BLB49__t0 WL0__t90 \$53__t4 VSS__t433 nfet_03v3 L=0.28U W=0.24U
+ AS=0.1022P AD=0.1684P PS=0.96U PD=1.72U
* device instance $199 r0 *1 220.61,1.83 nfet
X$199 VSS__t26 \$53__t2 \$280__t4 VSS__t561 nfet_03v3 L=0.28U W=0.36U
+ AS=0.1022P AD=0.169P PS=0.96U PD=1.28U
* device instance $200 r0 *1 221.79,1.83 nfet
X$200 \$53__t3 \$280__t2 VSS__t130 VSS__t689 nfet_03v3 L=0.28U W=0.36U
+ AS=0.169P AD=0.1022P PS=1.28U PD=0.96U
* device instance $201 r0 *1 224.21,1.77 nfet
X$201 \$283__t3 WL0__t155 BL50__t0 VSS__t306 nfet_03v3 L=0.28U W=0.24U
+ AS=0.1684P AD=0.1022P PS=1.72U PD=0.96U
* device instance $202 r0 *1 227.11,1.77 nfet
X$202 BLB50__t0 WL0__t89 \$54__t4 VSS__t434 nfet_03v3 L=0.28U W=0.24U
+ AS=0.1022P AD=0.1684P PS=0.96U PD=1.72U
* device instance $203 r0 *1 225.07,1.83 nfet
X$203 VSS__t13 \$54__t2 \$283__t4 VSS__t562 nfet_03v3 L=0.28U W=0.36U
+ AS=0.1022P AD=0.169P PS=0.96U PD=1.28U
* device instance $204 r0 *1 226.25,1.83 nfet
X$204 \$54__t3 \$283__t2 VSS__t131 VSS__t690 nfet_03v3 L=0.28U W=0.36U
+ AS=0.169P AD=0.1022P PS=1.28U PD=0.96U
* device instance $205 r0 *1 228.67,1.77 nfet
X$205 \$286__t3 WL0__t159 BL51__t0 VSS__t307 nfet_03v3 L=0.28U W=0.24U
+ AS=0.1684P AD=0.1022P PS=1.72U PD=0.96U
* device instance $206 r0 *1 231.57,1.77 nfet
X$206 BLB51__t0 WL0__t87 \$55__t4 VSS__t435 nfet_03v3 L=0.28U W=0.24U
+ AS=0.1022P AD=0.1684P PS=0.96U PD=1.72U
* device instance $207 r0 *1 229.53,1.83 nfet
X$207 VSS__t63 \$55__t2 \$286__t4 VSS__t563 nfet_03v3 L=0.28U W=0.36U
+ AS=0.1022P AD=0.169P PS=0.96U PD=1.28U
* device instance $208 r0 *1 230.71,1.83 nfet
X$208 \$55__t3 \$286__t2 VSS__t132 VSS__t691 nfet_03v3 L=0.28U W=0.36U
+ AS=0.169P AD=0.1022P PS=1.28U PD=0.96U
* device instance $209 r0 *1 233.13,1.77 nfet
X$209 \$289__t3 WL0__t163 BL52__t0 VSS__t308 nfet_03v3 L=0.28U W=0.24U
+ AS=0.1684P AD=0.1022P PS=1.72U PD=0.96U
* device instance $210 r0 *1 236.03,1.77 nfet
X$210 BLB52__t0 WL0__t86 \$56__t4 VSS__t436 nfet_03v3 L=0.28U W=0.24U
+ AS=0.1022P AD=0.1684P PS=0.96U PD=1.72U
* device instance $211 r0 *1 233.99,1.83 nfet
X$211 VSS__t41 \$56__t2 \$289__t4 VSS__t564 nfet_03v3 L=0.28U W=0.36U
+ AS=0.1022P AD=0.169P PS=0.96U PD=1.28U
* device instance $212 r0 *1 235.17,1.83 nfet
X$212 \$56__t3 \$289__t2 VSS__t149 VSS__t692 nfet_03v3 L=0.28U W=0.36U
+ AS=0.169P AD=0.1022P PS=1.28U PD=0.96U
* device instance $213 r0 *1 237.59,1.77 nfet
X$213 \$292__t3 WL0__t166 BL53__t0 VSS__t309 nfet_03v3 L=0.28U W=0.24U
+ AS=0.1684P AD=0.1022P PS=1.72U PD=0.96U
* device instance $214 r0 *1 240.49,1.77 nfet
X$214 BLB53__t0 WL0__t85 \$57__t4 VSS__t437 nfet_03v3 L=0.28U W=0.24U
+ AS=0.1022P AD=0.1684P PS=0.96U PD=1.72U
* device instance $215 r0 *1 238.45,1.83 nfet
X$215 VSS__t48 \$57__t2 \$292__t4 VSS__t565 nfet_03v3 L=0.28U W=0.36U
+ AS=0.1022P AD=0.169P PS=0.96U PD=1.28U
* device instance $216 r0 *1 239.63,1.83 nfet
X$216 \$57__t3 \$292__t2 VSS__t133 VSS__t693 nfet_03v3 L=0.28U W=0.36U
+ AS=0.169P AD=0.1022P PS=1.28U PD=0.96U
* device instance $217 r0 *1 242.05,1.77 nfet
X$217 \$295__t3 WL0__t169 BL54__t0 VSS__t310 nfet_03v3 L=0.28U W=0.24U
+ AS=0.1684P AD=0.1022P PS=1.72U PD=0.96U
* device instance $218 r0 *1 244.95,1.77 nfet
X$218 BLB54__t0 WL0__t84 \$58__t4 VSS__t438 nfet_03v3 L=0.28U W=0.24U
+ AS=0.1022P AD=0.1684P PS=0.96U PD=1.72U
* device instance $219 r0 *1 242.91,1.83 nfet
X$219 VSS__t51 \$58__t2 \$295__t4 VSS__t566 nfet_03v3 L=0.28U W=0.36U
+ AS=0.1022P AD=0.169P PS=0.96U PD=1.28U
* device instance $220 r0 *1 244.09,1.83 nfet
X$220 \$58__t3 \$295__t2 VSS__t252 VSS__t694 nfet_03v3 L=0.28U W=0.36U
+ AS=0.169P AD=0.1022P PS=1.28U PD=0.96U
* device instance $221 r0 *1 246.51,1.77 nfet
X$221 \$298__t3 WL0__t171 BL55__t0 VSS__t311 nfet_03v3 L=0.28U W=0.24U
+ AS=0.1684P AD=0.1022P PS=1.72U PD=0.96U
* device instance $222 r0 *1 249.41,1.77 nfet
X$222 BLB55__t0 WL0__t88 \$59__t4 VSS__t439 nfet_03v3 L=0.28U W=0.24U
+ AS=0.1022P AD=0.1684P PS=0.96U PD=1.72U
* device instance $223 r0 *1 247.37,1.83 nfet
X$223 VSS__t2 \$59__t2 \$298__t4 VSS__t567 nfet_03v3 L=0.28U W=0.36U AS=0.1022P
+ AD=0.169P PS=0.96U PD=1.28U
* device instance $224 r0 *1 248.55,1.83 nfet
X$224 \$59__t3 \$298__t2 VSS__t251 VSS__t695 nfet_03v3 L=0.28U W=0.36U
+ AS=0.169P AD=0.1022P PS=1.28U PD=0.96U
* device instance $225 r0 *1 250.97,1.77 nfet
X$225 \$301__t3 WL0__t183 BL56__t0 VSS__t312 nfet_03v3 L=0.28U W=0.24U
+ AS=0.1684P AD=0.1022P PS=1.72U PD=0.96U
* device instance $226 r0 *1 253.87,1.77 nfet
X$226 BLB56__t0 WL0__t92 \$60__t4 VSS__t440 nfet_03v3 L=0.28U W=0.24U
+ AS=0.1022P AD=0.1684P PS=0.96U PD=1.72U
* device instance $227 r0 *1 251.83,1.83 nfet
X$227 VSS__t89 \$60__t2 \$301__t4 VSS__t568 nfet_03v3 L=0.28U W=0.36U
+ AS=0.1022P AD=0.169P PS=0.96U PD=1.28U
* device instance $228 r0 *1 253.01,1.83 nfet
X$228 \$60__t3 \$301__t2 VSS__t248 VSS__t696 nfet_03v3 L=0.28U W=0.36U
+ AS=0.169P AD=0.1022P PS=1.28U PD=0.96U
* device instance $229 r0 *1 255.43,1.77 nfet
X$229 \$304__t3 WL0__t181 BL57__t0 VSS__t313 nfet_03v3 L=0.28U W=0.24U
+ AS=0.1684P AD=0.1022P PS=1.72U PD=0.96U
* device instance $230 r0 *1 258.33,1.77 nfet
X$230 BLB57__t0 WL0__t93 \$61__t4 VSS__t441 nfet_03v3 L=0.28U W=0.24U
+ AS=0.1022P AD=0.1684P PS=0.96U PD=1.72U
* device instance $231 r0 *1 256.29,1.83 nfet
X$231 VSS__t87 \$61__t2 \$304__t4 VSS__t569 nfet_03v3 L=0.28U W=0.36U
+ AS=0.1022P AD=0.169P PS=0.96U PD=1.28U
* device instance $232 r0 *1 257.47,1.83 nfet
X$232 \$61__t3 \$304__t2 VSS__t254 VSS__t697 nfet_03v3 L=0.28U W=0.36U
+ AS=0.169P AD=0.1022P PS=1.28U PD=0.96U
* device instance $233 r0 *1 259.89,1.77 nfet
X$233 \$307__t3 WL0__t188 BL58__t0 VSS__t314 nfet_03v3 L=0.28U W=0.24U
+ AS=0.1684P AD=0.1022P PS=1.72U PD=0.96U
* device instance $234 r0 *1 262.79,1.77 nfet
X$234 BLB58__t0 WL0__t94 \$62__t4 VSS__t442 nfet_03v3 L=0.28U W=0.24U
+ AS=0.1022P AD=0.1684P PS=0.96U PD=1.72U
* device instance $235 r0 *1 260.75,1.83 nfet
X$235 VSS__t98 \$62__t2 \$307__t4 VSS__t570 nfet_03v3 L=0.28U W=0.36U
+ AS=0.1022P AD=0.169P PS=0.96U PD=1.28U
* device instance $236 r0 *1 261.93,1.83 nfet
X$236 \$62__t3 \$307__t2 VSS__t246 VSS__t698 nfet_03v3 L=0.28U W=0.36U
+ AS=0.169P AD=0.1022P PS=1.28U PD=0.96U
* device instance $237 r0 *1 264.35,1.77 nfet
X$237 \$310__t3 WL0__t175 BL59__t0 VSS__t315 nfet_03v3 L=0.28U W=0.24U
+ AS=0.1684P AD=0.1022P PS=1.72U PD=0.96U
* device instance $238 r0 *1 267.25,1.77 nfet
X$238 BLB59__t0 WL0__t95 \$63__t4 VSS__t443 nfet_03v3 L=0.28U W=0.24U
+ AS=0.1022P AD=0.1684P PS=0.96U PD=1.72U
* device instance $239 r0 *1 265.21,1.83 nfet
X$239 VSS__t96 \$63__t2 \$310__t4 VSS__t571 nfet_03v3 L=0.28U W=0.36U
+ AS=0.1022P AD=0.169P PS=0.96U PD=1.28U
* device instance $240 r0 *1 266.39,1.83 nfet
X$240 \$63__t3 \$310__t2 VSS__t250 VSS__t699 nfet_03v3 L=0.28U W=0.36U
+ AS=0.169P AD=0.1022P PS=1.28U PD=0.96U
* device instance $241 r0 *1 268.81,1.77 nfet
X$241 \$313__t3 WL0__t172 BL60__t0 VSS__t316 nfet_03v3 L=0.28U W=0.24U
+ AS=0.1684P AD=0.1022P PS=1.72U PD=0.96U
* device instance $242 r0 *1 271.71,1.77 nfet
X$242 BLB60__t0 WL0__t109 \$64__t4 VSS__t444 nfet_03v3 L=0.28U W=0.24U
+ AS=0.1022P AD=0.1684P PS=0.96U PD=1.72U
* device instance $243 r0 *1 269.67,1.83 nfet
X$243 VSS__t76 \$64__t2 \$313__t4 VSS__t572 nfet_03v3 L=0.28U W=0.36U
+ AS=0.1022P AD=0.169P PS=0.96U PD=1.28U
* device instance $244 r0 *1 270.85,1.83 nfet
X$244 \$64__t3 \$313__t2 VSS__t253 VSS__t700 nfet_03v3 L=0.28U W=0.36U
+ AS=0.169P AD=0.1022P PS=1.28U PD=0.96U
* device instance $245 r0 *1 273.27,1.77 nfet
X$245 \$316__t3 WL0__t145 BL61__t0 VSS__t317 nfet_03v3 L=0.28U W=0.24U
+ AS=0.1684P AD=0.1022P PS=1.72U PD=0.96U
* device instance $246 r0 *1 276.17,1.77 nfet
X$246 BLB61__t0 WL0__t97 \$65__t4 VSS__t445 nfet_03v3 L=0.28U W=0.24U
+ AS=0.1022P AD=0.1684P PS=0.96U PD=1.72U
* device instance $247 r0 *1 274.13,1.83 nfet
X$247 VSS__t106 \$65__t2 \$316__t4 VSS__t573 nfet_03v3 L=0.28U W=0.36U
+ AS=0.1022P AD=0.169P PS=0.96U PD=1.28U
* device instance $248 r0 *1 275.31,1.83 nfet
X$248 \$65__t3 \$316__t2 VSS__t209 VSS__t701 nfet_03v3 L=0.28U W=0.36U
+ AS=0.169P AD=0.1022P PS=1.28U PD=0.96U
* device instance $249 r0 *1 277.73,1.77 nfet
X$249 \$319__t3 WL0__t129 BL62__t0 VSS__t318 nfet_03v3 L=0.28U W=0.24U
+ AS=0.1684P AD=0.1022P PS=1.72U PD=0.96U
* device instance $250 r0 *1 280.63,1.77 nfet
X$250 BLB62__t0 WL0__t98 \$66__t4 VSS__t446 nfet_03v3 L=0.28U W=0.24U
+ AS=0.1022P AD=0.1684P PS=0.96U PD=1.72U
* device instance $251 r0 *1 278.59,1.83 nfet
X$251 VSS__t112 \$66__t2 \$319__t4 VSS__t574 nfet_03v3 L=0.28U W=0.36U
+ AS=0.1022P AD=0.169P PS=0.96U PD=1.28U
* device instance $252 r0 *1 279.77,1.83 nfet
X$252 \$66__t3 \$319__t2 VSS__t220 VSS__t702 nfet_03v3 L=0.28U W=0.36U
+ AS=0.169P AD=0.1022P PS=1.28U PD=0.96U
* device instance $253 r0 *1 282.19,1.77 nfet
X$253 \$322__t3 WL0__t132 BL63__t0 VSS__t319 nfet_03v3 L=0.28U W=0.24U
+ AS=0.1684P AD=0.1022P PS=1.72U PD=0.96U
* device instance $254 r0 *1 285.09,1.77 nfet
X$254 BLB63__t0 WL0__t99 \$67__t4 VSS__t447 nfet_03v3 L=0.28U W=0.24U
+ AS=0.1022P AD=0.1684P PS=0.96U PD=1.72U
* device instance $255 r0 *1 283.05,1.83 nfet
X$255 VSS__t119 \$67__t2 \$322__t4 VSS__t575 nfet_03v3 L=0.28U W=0.36U
+ AS=0.1022P AD=0.169P PS=0.96U PD=1.28U
* device instance $256 r0 *1 284.23,1.83 nfet
X$256 \$67__t3 \$322__t2 VSS__t219 VSS__t703 nfet_03v3 L=0.28U W=0.36U
+ AS=0.169P AD=0.1022P PS=1.28U PD=0.96U
* device instance $257 r0 *1 286.65,1.77 nfet
X$257 \$325__t3 WL0 BL64__t0 VSS__t320 nfet_03v3 L=0.28U W=0.24U AS=0.1684P
+ AD=0.1022P PS=1.72U PD=0.96U
* device instance $258 r0 *1 289.55,1.77 nfet
X$258 BLB64__t0 WL0__t75 \$68__t4 VSS__t448 nfet_03v3 L=0.28U W=0.24U
+ AS=0.1022P AD=0.1684P PS=0.96U PD=1.72U
* device instance $259 r0 *1 287.51,1.83 nfet
X$259 VSS__t36 \$68__t2 \$325__t4 VSS__t576 nfet_03v3 L=0.28U W=0.36U
+ AS=0.1022P AD=0.169P PS=0.96U PD=1.28U
* device instance $260 r0 *1 288.69,1.83 nfet
X$260 \$68__t3 \$325__t2 VSS__t189 VSS__t704 nfet_03v3 L=0.28U W=0.36U
+ AS=0.169P AD=0.1022P PS=1.28U PD=0.96U
* device instance $261 r0 *1 291.11,1.77 nfet
X$261 \$328__t3 WL0__t193 BL65__t0 VSS__t321 nfet_03v3 L=0.28U W=0.24U
+ AS=0.1684P AD=0.1022P PS=1.72U PD=0.96U
* device instance $262 r0 *1 294.01,1.77 nfet
X$262 BLB65__t0 WL0__t74 \$69__t4 VSS__t449 nfet_03v3 L=0.28U W=0.24U
+ AS=0.1022P AD=0.1684P PS=0.96U PD=1.72U
* device instance $263 r0 *1 291.97,1.83 nfet
X$263 VSS__t22 \$69__t2 \$328__t4 VSS__t577 nfet_03v3 L=0.28U W=0.36U
+ AS=0.1022P AD=0.169P PS=0.96U PD=1.28U
* device instance $264 r0 *1 293.15,1.83 nfet
X$264 \$69__t3 \$328__t2 VSS__t180 VSS__t705 nfet_03v3 L=0.28U W=0.36U
+ AS=0.169P AD=0.1022P PS=1.28U PD=0.96U
* device instance $265 r0 *1 295.57,1.77 nfet
X$265 \$331__t3 WL0__t205 BL66__t0 VSS__t322 nfet_03v3 L=0.28U W=0.24U
+ AS=0.1684P AD=0.1022P PS=1.72U PD=0.96U
* device instance $266 r0 *1 298.47,1.77 nfet
X$266 BLB66__t0 WL0__t73 \$70__t4 VSS__t450 nfet_03v3 L=0.28U W=0.24U
+ AS=0.1022P AD=0.1684P PS=0.96U PD=1.72U
* device instance $267 r0 *1 296.43,1.83 nfet
X$267 VSS__t19 \$70__t2 \$331__t4 VSS__t578 nfet_03v3 L=0.28U W=0.36U
+ AS=0.1022P AD=0.169P PS=0.96U PD=1.28U
* device instance $268 r0 *1 297.61,1.83 nfet
X$268 \$70__t3 \$331__t2 VSS__t179 VSS__t706 nfet_03v3 L=0.28U W=0.36U
+ AS=0.169P AD=0.1022P PS=1.28U PD=0.96U
* device instance $269 r0 *1 300.03,1.77 nfet
X$269 \$334__t3 WL0__t198 BL67__t0 VSS__t323 nfet_03v3 L=0.28U W=0.24U
+ AS=0.1684P AD=0.1022P PS=1.72U PD=0.96U
* device instance $270 r0 *1 302.93,1.77 nfet
X$270 BLB67__t0 WL0__t71 \$71__t4 VSS__t451 nfet_03v3 L=0.28U W=0.24U
+ AS=0.1022P AD=0.1684P PS=0.96U PD=1.72U
* device instance $271 r0 *1 300.89,1.83 nfet
X$271 VSS__t31 \$71__t2 \$334__t4 VSS__t579 nfet_03v3 L=0.28U W=0.36U
+ AS=0.1022P AD=0.169P PS=0.96U PD=1.28U
* device instance $272 r0 *1 302.07,1.83 nfet
X$272 \$71__t3 \$334__t2 VSS__t178 VSS__t707 nfet_03v3 L=0.28U W=0.36U
+ AS=0.169P AD=0.1022P PS=1.28U PD=0.96U
* device instance $273 r0 *1 304.49,1.77 nfet
X$273 \$337__t3 WL0__t203 BL68__t0 VSS__t324 nfet_03v3 L=0.28U W=0.24U
+ AS=0.1684P AD=0.1022P PS=1.72U PD=0.96U
* device instance $274 r0 *1 307.39,1.77 nfet
X$274 BLB68__t0 WL0__t83 \$72__t4 VSS__t452 nfet_03v3 L=0.28U W=0.24U
+ AS=0.1022P AD=0.1684P PS=0.96U PD=1.72U
* device instance $275 r0 *1 305.35,1.83 nfet
X$275 VSS__t3 \$72__t2 \$337__t4 VSS__t580 nfet_03v3 L=0.28U W=0.36U AS=0.1022P
+ AD=0.169P PS=0.96U PD=1.28U
* device instance $276 r0 *1 306.53,1.83 nfet
X$276 \$72__t3 \$337__t2 VSS__t177 VSS__t708 nfet_03v3 L=0.28U W=0.36U
+ AS=0.169P AD=0.1022P PS=1.28U PD=0.96U
* device instance $277 r0 *1 308.95,1.77 nfet
X$277 \$340__t3 WL0__t239 BL69__t0 VSS__t325 nfet_03v3 L=0.28U W=0.24U
+ AS=0.1684P AD=0.1022P PS=1.72U PD=0.96U
* device instance $278 r0 *1 311.85,1.77 nfet
X$278 BLB69__t0 WL0__t69 \$73__t4 VSS__t453 nfet_03v3 L=0.28U W=0.24U
+ AS=0.1022P AD=0.1684P PS=0.96U PD=1.72U
* device instance $279 r0 *1 309.81,1.83 nfet
X$279 VSS__t105 \$73__t2 \$340__t4 VSS__t581 nfet_03v3 L=0.28U W=0.36U
+ AS=0.1022P AD=0.169P PS=0.96U PD=1.28U
* device instance $280 r0 *1 310.99,1.83 nfet
X$280 \$73__t3 \$340__t2 VSS__t176 VSS__t709 nfet_03v3 L=0.28U W=0.36U
+ AS=0.169P AD=0.1022P PS=1.28U PD=0.96U
* device instance $281 r0 *1 313.41,1.77 nfet
X$281 \$343__t3 WL0__t241 BL70__t0 VSS__t326 nfet_03v3 L=0.28U W=0.24U
+ AS=0.1684P AD=0.1022P PS=1.72U PD=0.96U
* device instance $282 r0 *1 316.31,1.77 nfet
X$282 BLB70__t0 WL0__t68 \$74__t4 VSS__t454 nfet_03v3 L=0.28U W=0.24U
+ AS=0.1022P AD=0.1684P PS=0.96U PD=1.72U
* device instance $283 r0 *1 314.27,1.83 nfet
X$283 VSS__t110 \$74__t2 \$343__t4 VSS__t582 nfet_03v3 L=0.28U W=0.36U
+ AS=0.1022P AD=0.169P PS=0.96U PD=1.28U
* device instance $284 r0 *1 315.45,1.83 nfet
X$284 \$74__t3 \$343__t2 VSS__t175 VSS__t710 nfet_03v3 L=0.28U W=0.36U
+ AS=0.169P AD=0.1022P PS=1.28U PD=0.96U
* device instance $285 r0 *1 317.87,1.77 nfet
X$285 \$346__t3 WL0__t244 BL71__t0 VSS__t327 nfet_03v3 L=0.28U W=0.24U
+ AS=0.1684P AD=0.1022P PS=1.72U PD=0.96U
* device instance $286 r0 *1 320.77,1.77 nfet
X$286 BLB71__t0 WL0__t122 \$75__t4 VSS__t455 nfet_03v3 L=0.28U W=0.24U
+ AS=0.1022P AD=0.1684P PS=0.96U PD=1.72U
* device instance $287 r0 *1 318.73,1.83 nfet
X$287 VSS__t115 \$75__t2 \$346__t4 VSS__t583 nfet_03v3 L=0.28U W=0.36U
+ AS=0.1022P AD=0.169P PS=0.96U PD=1.28U
* device instance $288 r0 *1 319.91,1.83 nfet
X$288 \$75__t3 \$346__t2 VSS__t174 VSS__t711 nfet_03v3 L=0.28U W=0.36U
+ AS=0.169P AD=0.1022P PS=1.28U PD=0.96U
* device instance $289 r0 *1 322.33,1.77 nfet
X$289 \$349__t3 WL0__t248 BL72__t0 VSS__t328 nfet_03v3 L=0.28U W=0.24U
+ AS=0.1684P AD=0.1022P PS=1.72U PD=0.96U
* device instance $290 r0 *1 325.23,1.77 nfet
X$290 BLB72__t0 WL0__t65 \$76__t4 VSS__t456 nfet_03v3 L=0.28U W=0.24U
+ AS=0.1022P AD=0.1684P PS=0.96U PD=1.72U
* device instance $291 r0 *1 323.19,1.83 nfet
X$291 VSS__t118 \$76__t2 \$349__t4 VSS__t584 nfet_03v3 L=0.28U W=0.36U
+ AS=0.1022P AD=0.169P PS=0.96U PD=1.28U
* device instance $292 r0 *1 324.37,1.83 nfet
X$292 \$76__t3 \$349__t2 VSS__t173 VSS__t712 nfet_03v3 L=0.28U W=0.36U
+ AS=0.169P AD=0.1022P PS=1.28U PD=0.96U
* device instance $293 r0 *1 326.79,1.77 nfet
X$293 \$352__t3 WL0__t251 BL73__t0 VSS__t329 nfet_03v3 L=0.28U W=0.24U
+ AS=0.1684P AD=0.1022P PS=1.72U PD=0.96U
* device instance $294 r0 *1 329.69,1.77 nfet
X$294 BLB73__t0 WL0__t64 \$77__t4 VSS__t457 nfet_03v3 L=0.28U W=0.24U
+ AS=0.1022P AD=0.1684P PS=0.96U PD=1.72U
* device instance $295 r0 *1 327.65,1.83 nfet
X$295 VSS__t123 \$77__t2 \$352__t4 VSS__t585 nfet_03v3 L=0.28U W=0.36U
+ AS=0.1022P AD=0.169P PS=0.96U PD=1.28U
* device instance $296 r0 *1 328.83,1.83 nfet
X$296 \$77__t3 \$352__t2 VSS__t172 VSS__t713 nfet_03v3 L=0.28U W=0.36U
+ AS=0.169P AD=0.1022P PS=1.28U PD=0.96U
* device instance $297 r0 *1 331.25,1.77 nfet
X$297 \$355__t3 WL0__t254 BL74__t0 VSS__t330 nfet_03v3 L=0.28U W=0.24U
+ AS=0.1684P AD=0.1022P PS=1.72U PD=0.96U
* device instance $298 r0 *1 334.15,1.77 nfet
X$298 BLB74__t0 WL0__t63 \$78__t4 VSS__t458 nfet_03v3 L=0.28U W=0.24U
+ AS=0.1022P AD=0.1684P PS=0.96U PD=1.72U
* device instance $299 r0 *1 332.11,1.83 nfet
X$299 VSS__t127 \$78__t2 \$355__t4 VSS__t586 nfet_03v3 L=0.28U W=0.36U
+ AS=0.1022P AD=0.169P PS=0.96U PD=1.28U
* device instance $300 r0 *1 333.29,1.83 nfet
X$300 \$78__t3 \$355__t2 VSS__t171 VSS__t714 nfet_03v3 L=0.28U W=0.36U
+ AS=0.169P AD=0.1022P PS=1.28U PD=0.96U
* device instance $301 r0 *1 335.71,1.77 nfet
X$301 \$358__t3 WL0__t225 BL75__t0 VSS__t331 nfet_03v3 L=0.28U W=0.24U
+ AS=0.1684P AD=0.1022P PS=1.72U PD=0.96U
* device instance $302 r0 *1 338.61,1.77 nfet
X$302 BLB75__t0 WL0__t61 \$79__t4 VSS__t459 nfet_03v3 L=0.28U W=0.24U
+ AS=0.1022P AD=0.1684P PS=0.96U PD=1.72U
* device instance $303 r0 *1 336.57,1.83 nfet
X$303 VSS__t78 \$79__t2 \$358__t4 VSS__t587 nfet_03v3 L=0.28U W=0.36U
+ AS=0.1022P AD=0.169P PS=0.96U PD=1.28U
* device instance $304 r0 *1 337.75,1.83 nfet
X$304 \$79__t3 \$358__t2 VSS__t170 VSS__t715 nfet_03v3 L=0.28U W=0.36U
+ AS=0.169P AD=0.1022P PS=1.28U PD=0.96U
* device instance $305 r0 *1 340.17,1.77 nfet
X$305 \$361__t3 WL0__t228 BL76__t0 VSS__t332 nfet_03v3 L=0.28U W=0.24U
+ AS=0.1684P AD=0.1022P PS=1.72U PD=0.96U
* device instance $306 r0 *1 343.07,1.77 nfet
X$306 BLB76__t0 WL0__t60 \$80__t4 VSS__t460 nfet_03v3 L=0.28U W=0.24U
+ AS=0.1022P AD=0.1684P PS=0.96U PD=1.72U
* device instance $307 r0 *1 341.03,1.83 nfet
X$307 VSS__t81 \$80__t2 \$361__t4 VSS__t588 nfet_03v3 L=0.28U W=0.36U
+ AS=0.1022P AD=0.169P PS=0.96U PD=1.28U
* device instance $308 r0 *1 342.21,1.83 nfet
X$308 \$80__t3 \$361__t2 VSS__t169 VSS__t716 nfet_03v3 L=0.28U W=0.36U
+ AS=0.169P AD=0.1022P PS=1.28U PD=0.96U
* device instance $309 r0 *1 344.63,1.77 nfet
X$309 \$364__t3 WL0__t238 BL77__t0 VSS__t333 nfet_03v3 L=0.28U W=0.24U
+ AS=0.1684P AD=0.1022P PS=1.72U PD=0.96U
* device instance $310 r0 *1 347.53,1.77 nfet
X$310 BLB77__t0 WL0__t59 \$81__t4 VSS__t461 nfet_03v3 L=0.28U W=0.24U
+ AS=0.1022P AD=0.1684P PS=0.96U PD=1.72U
* device instance $311 r0 *1 345.49,1.83 nfet
X$311 VSS__t85 \$81__t2 \$364__t4 VSS__t589 nfet_03v3 L=0.28U W=0.36U
+ AS=0.1022P AD=0.169P PS=0.96U PD=1.28U
* device instance $312 r0 *1 346.67,1.83 nfet
X$312 \$81__t3 \$364__t2 VSS__t168 VSS__t717 nfet_03v3 L=0.28U W=0.36U
+ AS=0.169P AD=0.1022P PS=1.28U PD=0.96U
* device instance $313 r0 *1 349.09,1.77 nfet
X$313 \$367__t3 WL0__t231 BL78__t0 VSS__t334 nfet_03v3 L=0.28U W=0.24U
+ AS=0.1684P AD=0.1022P PS=1.72U PD=0.96U
* device instance $314 r0 *1 351.99,1.77 nfet
X$314 BLB78__t0 WL0__t58 \$82__t4 VSS__t462 nfet_03v3 L=0.28U W=0.24U
+ AS=0.1022P AD=0.1684P PS=0.96U PD=1.72U
* device instance $315 r0 *1 349.95,1.83 nfet
X$315 VSS__t88 \$82__t2 \$367__t4 VSS__t590 nfet_03v3 L=0.28U W=0.36U
+ AS=0.1022P AD=0.169P PS=0.96U PD=1.28U
* device instance $316 r0 *1 351.13,1.83 nfet
X$316 \$82__t3 \$367__t2 VSS__t167 VSS__t718 nfet_03v3 L=0.28U W=0.36U
+ AS=0.169P AD=0.1022P PS=1.28U PD=0.96U
* device instance $317 r0 *1 353.55,1.77 nfet
X$317 \$370__t3 WL0__t196 BL79__t0 VSS__t335 nfet_03v3 L=0.28U W=0.24U
+ AS=0.1684P AD=0.1022P PS=1.72U PD=0.96U
* device instance $318 r0 *1 356.45,1.77 nfet
X$318 BLB79__t0 WL0__t108 \$83__t4 VSS__t463 nfet_03v3 L=0.28U W=0.24U
+ AS=0.1022P AD=0.1684P PS=0.96U PD=1.72U
* device instance $319 r0 *1 354.41,1.83 nfet
X$319 VSS__t91 \$83__t2 \$370__t4 VSS__t591 nfet_03v3 L=0.28U W=0.36U
+ AS=0.1022P AD=0.169P PS=0.96U PD=1.28U
* device instance $320 r0 *1 355.59,1.83 nfet
X$320 \$83__t3 \$370__t2 VSS__t166 VSS__t719 nfet_03v3 L=0.28U W=0.36U
+ AS=0.169P AD=0.1022P PS=1.28U PD=0.96U
* device instance $321 r0 *1 358.01,1.77 nfet
X$321 \$373__t3 WL0__t143 BL80__t0 VSS__t336 nfet_03v3 L=0.28U W=0.24U
+ AS=0.1684P AD=0.1022P PS=1.72U PD=0.96U
* device instance $322 r0 *1 360.91,1.77 nfet
X$322 BLB80__t0 WL0__t119 \$84__t4 VSS__t464 nfet_03v3 L=0.28U W=0.24U
+ AS=0.1022P AD=0.1684P PS=0.96U PD=1.72U
* device instance $323 r0 *1 358.87,1.83 nfet
X$323 VSS__t65 \$84__t2 \$373__t4 VSS__t592 nfet_03v3 L=0.28U W=0.36U
+ AS=0.1022P AD=0.169P PS=0.96U PD=1.28U
* device instance $324 r0 *1 360.05,1.83 nfet
X$324 \$84__t3 \$373__t2 VSS__t182 VSS__t720 nfet_03v3 L=0.28U W=0.36U
+ AS=0.169P AD=0.1022P PS=1.28U PD=0.96U
* device instance $325 r0 *1 362.47,1.77 nfet
X$325 \$376__t3 WL0__t153 BL81__t0 VSS__t337 nfet_03v3 L=0.28U W=0.24U
+ AS=0.1684P AD=0.1022P PS=1.72U PD=0.96U
* device instance $326 r0 *1 365.37,1.77 nfet
X$326 BLB81__t0 WL0__t123 \$85__t4 VSS__t465 nfet_03v3 L=0.28U W=0.24U
+ AS=0.1022P AD=0.1684P PS=0.96U PD=1.72U
* device instance $327 r0 *1 363.33,1.83 nfet
X$327 VSS__t73 \$85__t2 \$376__t4 VSS__t593 nfet_03v3 L=0.28U W=0.36U
+ AS=0.1022P AD=0.169P PS=0.96U PD=1.28U
* device instance $328 r0 *1 364.51,1.83 nfet
X$328 \$85__t3 \$376__t2 VSS__t183 VSS__t721 nfet_03v3 L=0.28U W=0.36U
+ AS=0.169P AD=0.1022P PS=1.28U PD=0.96U
* device instance $329 r0 *1 366.93,1.77 nfet
X$329 \$379__t3 WL0__t234 BL82__t0 VSS__t338 nfet_03v3 L=0.28U W=0.24U
+ AS=0.1684P AD=0.1022P PS=1.72U PD=0.96U
* device instance $330 r0 *1 369.83,1.77 nfet
X$330 BLB82__t0 WL0__t125 \$86__t4 VSS__t466 nfet_03v3 L=0.28U W=0.24U
+ AS=0.1022P AD=0.1684P PS=0.96U PD=1.72U
* device instance $331 r0 *1 367.79,1.83 nfet
X$331 VSS__t70 \$86__t2 \$379__t4 VSS__t594 nfet_03v3 L=0.28U W=0.36U
+ AS=0.1022P AD=0.169P PS=0.96U PD=1.28U
* device instance $332 r0 *1 368.97,1.83 nfet
X$332 \$86__t3 \$379__t2 VSS__t184 VSS__t722 nfet_03v3 L=0.28U W=0.36U
+ AS=0.169P AD=0.1022P PS=1.28U PD=0.96U
* device instance $333 r0 *1 371.39,1.77 nfet
X$333 \$382__t3 WL0__t229 BL83__t0 VSS__t339 nfet_03v3 L=0.28U W=0.24U
+ AS=0.1684P AD=0.1022P PS=1.72U PD=0.96U
* device instance $334 r0 *1 374.29,1.77 nfet
X$334 BLB83__t0 WL0__t128 \$87__t4 VSS__t467 nfet_03v3 L=0.28U W=0.24U
+ AS=0.1022P AD=0.1684P PS=0.96U PD=1.72U
* device instance $335 r0 *1 372.25,1.83 nfet
X$335 VSS__t68 \$87__t2 \$382__t4 VSS__t595 nfet_03v3 L=0.28U W=0.36U
+ AS=0.1022P AD=0.169P PS=0.96U PD=1.28U
* device instance $336 r0 *1 373.43,1.83 nfet
X$336 \$87__t3 \$382__t2 VSS__t185 VSS__t723 nfet_03v3 L=0.28U W=0.36U
+ AS=0.169P AD=0.1022P PS=1.28U PD=0.96U
* device instance $337 r0 *1 375.85,1.77 nfet
X$337 \$385__t3 WL0__t252 BL84__t0 VSS__t340 nfet_03v3 L=0.28U W=0.24U
+ AS=0.1684P AD=0.1022P PS=1.72U PD=0.96U
* device instance $338 r0 *1 378.75,1.77 nfet
X$338 BLB84__t0 WL0__t113 \$88__t4 VSS__t468 nfet_03v3 L=0.28U W=0.24U
+ AS=0.1022P AD=0.1684P PS=0.96U PD=1.72U
* device instance $339 r0 *1 376.71,1.83 nfet
X$339 VSS__t75 \$88__t2 \$385__t4 VSS__t596 nfet_03v3 L=0.28U W=0.36U
+ AS=0.1022P AD=0.169P PS=0.96U PD=1.28U
* device instance $340 r0 *1 377.89,1.83 nfet
X$340 \$88__t3 \$385__t2 VSS__t186 VSS__t724 nfet_03v3 L=0.28U W=0.36U
+ AS=0.169P AD=0.1022P PS=1.28U PD=0.96U
* device instance $341 r0 *1 380.31,1.77 nfet
X$341 \$388__t3 WL0__t243 BL85__t0 VSS__t341 nfet_03v3 L=0.28U W=0.24U
+ AS=0.1684P AD=0.1022P PS=1.72U PD=0.96U
* device instance $342 r0 *1 383.21,1.77 nfet
X$342 BLB85__t0 WL0__t110 \$89__t4 VSS__t469 nfet_03v3 L=0.28U W=0.24U
+ AS=0.1022P AD=0.1684P PS=0.96U PD=1.72U
* device instance $343 r0 *1 381.17,1.83 nfet
X$343 VSS__t61 \$89__t2 \$388__t4 VSS__t597 nfet_03v3 L=0.28U W=0.36U
+ AS=0.1022P AD=0.169P PS=0.96U PD=1.28U
* device instance $344 r0 *1 382.35,1.83 nfet
X$344 \$89__t3 \$388__t2 VSS__t187 VSS__t725 nfet_03v3 L=0.28U W=0.36U
+ AS=0.169P AD=0.1022P PS=1.28U PD=0.96U
* device instance $345 r0 *1 384.77,1.77 nfet
X$345 \$391__t3 WL0__t240 BL86__t0 VSS__t342 nfet_03v3 L=0.28U W=0.24U
+ AS=0.1684P AD=0.1022P PS=1.72U PD=0.96U
* device instance $346 r0 *1 387.67,1.77 nfet
X$346 BLB86__t0 WL0__t115 \$90__t4 VSS__t470 nfet_03v3 L=0.28U W=0.24U
+ AS=0.1022P AD=0.1684P PS=0.96U PD=1.72U
* device instance $347 r0 *1 385.63,1.83 nfet
X$347 VSS__t59 \$90__t2 \$391__t4 VSS__t598 nfet_03v3 L=0.28U W=0.36U
+ AS=0.1022P AD=0.169P PS=0.96U PD=1.28U
* device instance $348 r0 *1 386.81,1.83 nfet
X$348 \$90__t3 \$391__t2 VSS__t188 VSS__t726 nfet_03v3 L=0.28U W=0.36U
+ AS=0.169P AD=0.1022P PS=1.28U PD=0.96U
* device instance $349 r0 *1 389.23,1.77 nfet
X$349 \$394__t3 WL0__t194 BL87__t0 VSS__t343 nfet_03v3 L=0.28U W=0.24U
+ AS=0.1684P AD=0.1022P PS=1.72U PD=0.96U
* device instance $350 r0 *1 392.13,1.77 nfet
X$350 BLB87__t0 WL0__t118 \$91__t4 VSS__t471 nfet_03v3 L=0.28U W=0.24U
+ AS=0.1022P AD=0.1684P PS=0.96U PD=1.72U
* device instance $351 r0 *1 390.09,1.83 nfet
X$351 VSS__t57 \$91__t2 \$394__t4 VSS__t599 nfet_03v3 L=0.28U W=0.36U
+ AS=0.1022P AD=0.169P PS=0.96U PD=1.28U
* device instance $352 r0 *1 391.27,1.83 nfet
X$352 \$91__t3 \$394__t2 VSS__t198 VSS__t727 nfet_03v3 L=0.28U W=0.36U
+ AS=0.169P AD=0.1022P PS=1.28U PD=0.96U
* device instance $353 r0 *1 393.69,1.77 nfet
X$353 \$397__t3 WL0__t218 BL88__t0 VSS__t344 nfet_03v3 L=0.28U W=0.24U
+ AS=0.1684P AD=0.1022P PS=1.72U PD=0.96U
* device instance $354 r0 *1 396.59,1.77 nfet
X$354 BLB88__t0 WL0__t126 \$92__t4 VSS__t472 nfet_03v3 L=0.28U W=0.24U
+ AS=0.1022P AD=0.1684P PS=0.96U PD=1.72U
* device instance $355 r0 *1 394.55,1.83 nfet
X$355 VSS__t16 \$92__t2 \$397__t4 VSS__t600 nfet_03v3 L=0.28U W=0.36U
+ AS=0.1022P AD=0.169P PS=0.96U PD=1.28U
* device instance $356 r0 *1 395.73,1.83 nfet
X$356 \$92__t3 \$397__t2 VSS__t190 VSS__t728 nfet_03v3 L=0.28U W=0.36U
+ AS=0.169P AD=0.1022P PS=1.28U PD=0.96U
* device instance $357 r0 *1 398.15,1.77 nfet
X$357 \$400__t3 WL0__t210 BL89__t0 VSS__t345 nfet_03v3 L=0.28U W=0.24U
+ AS=0.1684P AD=0.1022P PS=1.72U PD=0.96U
* device instance $358 r0 *1 401.05,1.77 nfet
X$358 BLB89__t0 WL0__t124 \$93__t4 VSS__t473 nfet_03v3 L=0.28U W=0.24U
+ AS=0.1022P AD=0.1684P PS=0.96U PD=1.72U
* device instance $359 r0 *1 399.01,1.83 nfet
X$359 VSS__t12 \$93__t2 \$400__t4 VSS__t601 nfet_03v3 L=0.28U W=0.36U
+ AS=0.1022P AD=0.169P PS=0.96U PD=1.28U
* device instance $360 r0 *1 400.19,1.83 nfet
X$360 \$93__t3 \$400__t2 VSS__t191 VSS__t729 nfet_03v3 L=0.28U W=0.36U
+ AS=0.169P AD=0.1022P PS=1.28U PD=0.96U
* device instance $361 r0 *1 402.61,1.77 nfet
X$361 \$403__t3 WL0__t206 BL90__t0 VSS__t346 nfet_03v3 L=0.28U W=0.24U
+ AS=0.1684P AD=0.1022P PS=1.72U PD=0.96U
* device instance $362 r0 *1 405.51,1.77 nfet
X$362 BLB90__t0 WL0__t70 \$94__t4 VSS__t474 nfet_03v3 L=0.28U W=0.24U
+ AS=0.1022P AD=0.1684P PS=0.96U PD=1.72U
* device instance $363 r0 *1 403.47,1.83 nfet
X$363 VSS__t9 \$94__t2 \$403__t4 VSS__t602 nfet_03v3 L=0.28U W=0.36U AS=0.1022P
+ AD=0.169P PS=0.96U PD=1.28U
* device instance $364 r0 *1 404.65,1.83 nfet
X$364 \$94__t3 \$403__t2 VSS__t192 VSS__t730 nfet_03v3 L=0.28U W=0.36U
+ AS=0.169P AD=0.1022P PS=1.28U PD=0.96U
* device instance $365 r0 *1 407.07,1.77 nfet
X$365 \$406__t3 WL0__t209 BL91__t0 VSS__t347 nfet_03v3 L=0.28U W=0.24U
+ AS=0.1684P AD=0.1022P PS=1.72U PD=0.96U
* device instance $366 r0 *1 409.97,1.77 nfet
X$366 BLB91__t0 WL0__t81 \$95__t4 VSS__t475 nfet_03v3 L=0.28U W=0.24U
+ AS=0.1022P AD=0.1684P PS=0.96U PD=1.72U
* device instance $367 r0 *1 407.93,1.83 nfet
X$367 VSS__t8 \$95__t2 \$406__t4 VSS__t603 nfet_03v3 L=0.28U W=0.36U AS=0.1022P
+ AD=0.169P PS=0.96U PD=1.28U
* device instance $368 r0 *1 409.11,1.83 nfet
X$368 \$95__t3 \$406__t2 VSS__t193 VSS__t731 nfet_03v3 L=0.28U W=0.36U
+ AS=0.169P AD=0.1022P PS=1.28U PD=0.96U
* device instance $369 r0 *1 411.53,1.77 nfet
X$369 \$409__t3 WL0__t222 BL92__t0 VSS__t348 nfet_03v3 L=0.28U W=0.24U
+ AS=0.1684P AD=0.1022P PS=1.72U PD=0.96U
* device instance $370 r0 *1 414.43,1.77 nfet
X$370 BLB92__t0 WL0__t80 \$96__t4 VSS__t476 nfet_03v3 L=0.28U W=0.24U
+ AS=0.1022P AD=0.1684P PS=0.96U PD=1.72U
* device instance $371 r0 *1 412.39,1.83 nfet
X$371 VSS__t5 \$96__t2 \$409__t4 VSS__t604 nfet_03v3 L=0.28U W=0.36U AS=0.1022P
+ AD=0.169P PS=0.96U PD=1.28U
* device instance $372 r0 *1 413.57,1.83 nfet
X$372 \$96__t3 \$409__t2 VSS__t194 VSS__t732 nfet_03v3 L=0.28U W=0.36U
+ AS=0.169P AD=0.1022P PS=1.28U PD=0.96U
* device instance $373 r0 *1 415.99,1.77 nfet
X$373 \$412__t3 WL0__t214 BL93__t0 VSS__t349 nfet_03v3 L=0.28U W=0.24U
+ AS=0.1684P AD=0.1022P PS=1.72U PD=0.96U
* device instance $374 r0 *1 418.89,1.77 nfet
X$374 BLB93__t0 WL0__t79 \$97__t4 VSS__t477 nfet_03v3 L=0.28U W=0.24U
+ AS=0.1022P AD=0.1684P PS=0.96U PD=1.72U
* device instance $375 r0 *1 416.85,1.83 nfet
X$375 VSS__t35 \$97__t2 \$412__t4 VSS__t605 nfet_03v3 L=0.28U W=0.36U
+ AS=0.1022P AD=0.169P PS=0.96U PD=1.28U
* device instance $376 r0 *1 418.03,1.83 nfet
X$376 \$97__t3 \$412__t2 VSS__t195 VSS__t733 nfet_03v3 L=0.28U W=0.36U
+ AS=0.169P AD=0.1022P PS=1.28U PD=0.96U
* device instance $377 r0 *1 420.45,1.77 nfet
X$377 \$415__t3 WL0__t217 BL94__t0 VSS__t350 nfet_03v3 L=0.28U W=0.24U
+ AS=0.1684P AD=0.1022P PS=1.72U PD=0.96U
* device instance $378 r0 *1 423.35,1.77 nfet
X$378 BLB94__t0 WL0__t78 \$98__t4 VSS__t478 nfet_03v3 L=0.28U W=0.24U
+ AS=0.1022P AD=0.1684P PS=0.96U PD=1.72U
* device instance $379 r0 *1 421.31,1.83 nfet
X$379 VSS__t30 \$98__t2 \$415__t4 VSS__t606 nfet_03v3 L=0.28U W=0.36U
+ AS=0.1022P AD=0.169P PS=0.96U PD=1.28U
* device instance $380 r0 *1 422.49,1.83 nfet
X$380 \$98__t3 \$415__t2 VSS__t196 VSS__t734 nfet_03v3 L=0.28U W=0.36U
+ AS=0.169P AD=0.1022P PS=1.28U PD=0.96U
* device instance $381 r0 *1 424.91,1.77 nfet
X$381 \$418__t3 WL0__t221 BL95__t0 VSS__t351 nfet_03v3 L=0.28U W=0.24U
+ AS=0.1684P AD=0.1022P PS=1.72U PD=0.96U
* device instance $382 r0 *1 427.81,1.77 nfet
X$382 BLB95__t0 WL0__t76 \$99__t4 VSS__t479 nfet_03v3 L=0.28U W=0.24U
+ AS=0.1022P AD=0.1684P PS=0.96U PD=1.72U
* device instance $383 r0 *1 425.77,1.83 nfet
X$383 VSS__t28 \$99__t2 \$418__t4 VSS__t607 nfet_03v3 L=0.28U W=0.36U
+ AS=0.1022P AD=0.169P PS=0.96U PD=1.28U
* device instance $384 r0 *1 426.95,1.83 nfet
X$384 \$99__t3 \$418__t2 VSS__t197 VSS__t735 nfet_03v3 L=0.28U W=0.36U
+ AS=0.169P AD=0.1022P PS=1.28U PD=0.96U
* device instance $385 r0 *1 429.37,1.77 nfet
X$385 \$421__t3 WL0__t204 BL96__t0 VSS__t352 nfet_03v3 L=0.28U W=0.24U
+ AS=0.1684P AD=0.1022P PS=1.72U PD=0.96U
* device instance $386 r0 *1 432.27,1.77 nfet
X$386 BLB96__t0 WL0__t44 \$100__t4 VSS__t480 nfet_03v3 L=0.28U W=0.24U
+ AS=0.1022P AD=0.1684P PS=0.96U PD=1.72U
* device instance $387 r0 *1 430.23,1.83 nfet
X$387 VSS__t62 \$100__t2 \$421__t4 VSS__t608 nfet_03v3 L=0.28U W=0.36U
+ AS=0.1022P AD=0.169P PS=0.96U PD=1.28U
* device instance $388 r0 *1 431.41,1.83 nfet
X$388 \$100__t3 \$421__t2 VSS__t140 VSS__t736 nfet_03v3 L=0.28U W=0.36U
+ AS=0.169P AD=0.1022P PS=1.28U PD=0.96U
* device instance $389 r0 *1 433.83,1.77 nfet
X$389 \$424__t3 WL0__t255 BL97__t0 VSS__t353 nfet_03v3 L=0.28U W=0.24U
+ AS=0.1684P AD=0.1022P PS=1.72U PD=0.96U
* device instance $390 r0 *1 436.73,1.77 nfet
X$390 BLB97__t0 WL0__t41 \$101__t4 VSS__t481 nfet_03v3 L=0.28U W=0.24U
+ AS=0.1022P AD=0.1684P PS=0.96U PD=1.72U
* device instance $391 r0 *1 434.69,1.83 nfet
X$391 VSS__t66 \$101__t2 \$424__t4 VSS__t609 nfet_03v3 L=0.28U W=0.36U
+ AS=0.1022P AD=0.169P PS=0.96U PD=1.28U
* device instance $392 r0 *1 435.87,1.83 nfet
X$392 \$101__t3 \$424__t2 VSS__t139 VSS__t737 nfet_03v3 L=0.28U W=0.36U
+ AS=0.169P AD=0.1022P PS=1.28U PD=0.96U
* device instance $393 r0 *1 438.29,1.77 nfet
X$393 \$427__t3 WL0__t223 BL98__t0 VSS__t354 nfet_03v3 L=0.28U W=0.24U
+ AS=0.1684P AD=0.1022P PS=1.72U PD=0.96U
* device instance $394 r0 *1 441.19,1.77 nfet
X$394 BLB98__t0 WL0__t40 \$102__t4 VSS__t482 nfet_03v3 L=0.28U W=0.24U
+ AS=0.1022P AD=0.1684P PS=0.96U PD=1.72U
* device instance $395 r0 *1 439.15,1.83 nfet
X$395 VSS__t69 \$102__t2 \$427__t4 VSS__t610 nfet_03v3 L=0.28U W=0.36U
+ AS=0.1022P AD=0.169P PS=0.96U PD=1.28U
* device instance $396 r0 *1 440.33,1.83 nfet
X$396 \$102__t3 \$427__t2 VSS__t138 VSS__t738 nfet_03v3 L=0.28U W=0.36U
+ AS=0.169P AD=0.1022P PS=1.28U PD=0.96U
* device instance $397 r0 *1 442.75,1.77 nfet
X$397 \$430__t3 WL0__t232 BL99__t0 VSS__t355 nfet_03v3 L=0.28U W=0.24U
+ AS=0.1684P AD=0.1022P PS=1.72U PD=0.96U
* device instance $398 r0 *1 445.65,1.77 nfet
X$398 BLB99__t0 WL0__t7 \$103__t4 VSS__t483 nfet_03v3 L=0.28U W=0.24U
+ AS=0.1022P AD=0.1684P PS=0.96U PD=1.72U
* device instance $399 r0 *1 443.61,1.83 nfet
X$399 VSS__t71 \$103__t2 \$430__t4 VSS__t611 nfet_03v3 L=0.28U W=0.36U
+ AS=0.1022P AD=0.169P PS=0.96U PD=1.28U
* device instance $400 r0 *1 444.79,1.83 nfet
X$400 \$103__t3 \$430__t2 VSS__t137 VSS__t739 nfet_03v3 L=0.28U W=0.36U
+ AS=0.169P AD=0.1022P PS=1.28U PD=0.96U
* device instance $401 r0 *1 447.21,1.77 nfet
X$401 \$433__t3 WL0__t136 BL100__t0 VSS__t356 nfet_03v3 L=0.28U W=0.24U
+ AS=0.1684P AD=0.1022P PS=1.72U PD=0.96U
* device instance $402 r0 *1 450.11,1.77 nfet
X$402 BLB100__t0 WL0__t10 \$104__t4 VSS__t484 nfet_03v3 L=0.28U W=0.24U
+ AS=0.1022P AD=0.1684P PS=0.96U PD=1.72U
* device instance $403 r0 *1 448.07,1.83 nfet
X$403 VSS__t74 \$104__t2 \$433__t4 VSS__t612 nfet_03v3 L=0.28U W=0.36U
+ AS=0.1022P AD=0.169P PS=0.96U PD=1.28U
* device instance $404 r0 *1 449.25,1.83 nfet
X$404 \$104__t3 \$433__t2 VSS__t136 VSS__t740 nfet_03v3 L=0.28U W=0.36U
+ AS=0.169P AD=0.1022P PS=1.28U PD=0.96U
* device instance $405 r0 *1 451.67,1.77 nfet
X$405 \$436__t3 WL0__t146 BL101__t0 VSS__t357 nfet_03v3 L=0.28U W=0.24U
+ AS=0.1684P AD=0.1022P PS=1.72U PD=0.96U
* device instance $406 r0 *1 454.57,1.77 nfet
X$406 BLB101__t0 WL0__t19 \$105__t4 VSS__t485 nfet_03v3 L=0.28U W=0.24U
+ AS=0.1022P AD=0.1684P PS=0.96U PD=1.72U
* device instance $407 r0 *1 452.53,1.83 nfet
X$407 VSS__t38 \$105__t2 \$436__t4 VSS__t613 nfet_03v3 L=0.28U W=0.36U
+ AS=0.1022P AD=0.169P PS=0.96U PD=1.28U
* device instance $408 r0 *1 453.71,1.83 nfet
X$408 \$105__t3 \$436__t2 VSS__t135 VSS__t741 nfet_03v3 L=0.28U W=0.36U
+ AS=0.169P AD=0.1022P PS=1.28U PD=0.96U
* device instance $409 r0 *1 456.13,1.77 nfet
X$409 \$439__t3 WL0__t130 BL102__t0 VSS__t358 nfet_03v3 L=0.28U W=0.24U
+ AS=0.1684P AD=0.1022P PS=1.72U PD=0.96U
* device instance $410 r0 *1 459.03,1.77 nfet
X$410 BLB102__t0 WL0__t11 \$106__t4 VSS__t486 nfet_03v3 L=0.28U W=0.24U
+ AS=0.1022P AD=0.1684P PS=0.96U PD=1.72U
* device instance $411 r0 *1 456.99,1.83 nfet
X$411 VSS__t42 \$106__t2 \$439__t4 VSS__t614 nfet_03v3 L=0.28U W=0.36U
+ AS=0.1022P AD=0.169P PS=0.96U PD=1.28U
* device instance $412 r0 *1 458.17,1.83 nfet
X$412 \$106__t3 \$439__t2 VSS__t134 VSS__t742 nfet_03v3 L=0.28U W=0.36U
+ AS=0.169P AD=0.1022P PS=1.28U PD=0.96U
* device instance $413 r0 *1 460.59,1.77 nfet
X$413 \$442__t3 WL0__t176 BL103__t0 VSS__t359 nfet_03v3 L=0.28U W=0.24U
+ AS=0.1684P AD=0.1022P PS=1.72U PD=0.96U
* device instance $414 r0 *1 463.49,1.77 nfet
X$414 BLB103__t0 WL0__t4 \$107__t4 VSS__t487 nfet_03v3 L=0.28U W=0.24U
+ AS=0.1022P AD=0.1684P PS=0.96U PD=1.72U
* device instance $415 r0 *1 461.45,1.83 nfet
X$415 VSS__t46 \$107__t2 \$442__t4 VSS__t615 nfet_03v3 L=0.28U W=0.36U
+ AS=0.1022P AD=0.169P PS=0.96U PD=1.28U
* device instance $416 r0 *1 462.63,1.83 nfet
X$416 \$107__t3 \$442__t2 VSS__t181 VSS__t743 nfet_03v3 L=0.28U W=0.36U
+ AS=0.169P AD=0.1022P PS=1.28U PD=0.96U
* device instance $417 r0 *1 465.05,1.77 nfet
X$417 \$445__t3 WL0__t249 BL104__t0 VSS__t360 nfet_03v3 L=0.28U W=0.24U
+ AS=0.1684P AD=0.1022P PS=1.72U PD=0.96U
* device instance $418 r0 *1 467.95,1.77 nfet
X$418 BLB104__t0 WL0__t32 \$108__t4 VSS__t488 nfet_03v3 L=0.28U W=0.24U
+ AS=0.1022P AD=0.1684P PS=0.96U PD=1.72U
* device instance $419 r0 *1 465.91,1.83 nfet
X$419 VSS__t122 \$108__t2 \$445__t4 VSS__t616 nfet_03v3 L=0.28U W=0.36U
+ AS=0.1022P AD=0.169P PS=0.96U PD=1.28U
* device instance $420 r0 *1 467.09,1.83 nfet
X$420 \$108__t3 \$445__t2 VSS__t148 VSS__t744 nfet_03v3 L=0.28U W=0.36U
+ AS=0.169P AD=0.1022P PS=1.28U PD=0.96U
* device instance $421 r0 *1 469.51,1.77 nfet
X$421 \$448__t3 WL0__t245 BL105__t0 VSS__t361 nfet_03v3 L=0.28U W=0.24U
+ AS=0.1684P AD=0.1022P PS=1.72U PD=0.96U
* device instance $422 r0 *1 472.41,1.77 nfet
X$422 BLB105__t0 WL0__t34 \$109__t4 VSS__t489 nfet_03v3 L=0.28U W=0.24U
+ AS=0.1022P AD=0.1684P PS=0.96U PD=1.72U
* device instance $423 r0 *1 470.37,1.83 nfet
X$423 VSS__t111 \$109__t2 \$448__t4 VSS__t617 nfet_03v3 L=0.28U W=0.36U
+ AS=0.1022P AD=0.169P PS=0.96U PD=1.28U
* device instance $424 r0 *1 471.55,1.83 nfet
X$424 \$109__t3 \$448__t2 VSS__t147 VSS__t745 nfet_03v3 L=0.28U W=0.36U
+ AS=0.169P AD=0.1022P PS=1.28U PD=0.96U
* device instance $425 r0 *1 473.97,1.77 nfet
X$425 \$451__t3 WL0__t242 BL106__t0 VSS__t362 nfet_03v3 L=0.28U W=0.24U
+ AS=0.1684P AD=0.1022P PS=1.72U PD=0.96U
* device instance $426 r0 *1 476.87,1.77 nfet
X$426 BLB106__t0 WL0__t37 \$110__t4 VSS__t490 nfet_03v3 L=0.28U W=0.24U
+ AS=0.1022P AD=0.1684P PS=0.96U PD=1.72U
* device instance $427 r0 *1 474.83,1.83 nfet
X$427 VSS__t4 \$110__t2 \$451__t4 VSS__t618 nfet_03v3 L=0.28U W=0.36U
+ AS=0.1022P AD=0.169P PS=0.96U PD=1.28U
* device instance $428 r0 *1 476.01,1.83 nfet
X$428 \$110__t3 \$451__t2 VSS__t146 VSS__t746 nfet_03v3 L=0.28U W=0.36U
+ AS=0.169P AD=0.1022P PS=1.28U PD=0.96U
* device instance $429 r0 *1 478.43,1.77 nfet
X$429 \$454__t3 WL0__t230 BL107__t0 VSS__t363 nfet_03v3 L=0.28U W=0.24U
+ AS=0.1684P AD=0.1022P PS=1.72U PD=0.96U
* device instance $430 r0 *1 481.33,1.77 nfet
X$430 BLB107__t0 WL0__t36 \$111__t4 VSS__t491 nfet_03v3 L=0.28U W=0.24U
+ AS=0.1022P AD=0.1684P PS=0.96U PD=1.72U
* device instance $431 r0 *1 479.29,1.83 nfet
X$431 VSS__t32 \$111__t2 \$454__t4 VSS__t619 nfet_03v3 L=0.28U W=0.36U
+ AS=0.1022P AD=0.169P PS=0.96U PD=1.28U
* device instance $432 r0 *1 480.47,1.83 nfet
X$432 \$111__t3 \$454__t2 VSS__t145 VSS__t747 nfet_03v3 L=0.28U W=0.36U
+ AS=0.169P AD=0.1022P PS=1.28U PD=0.96U
* device instance $433 r0 *1 482.89,1.77 nfet
X$433 \$457__t3 WL0__t201 BL108__t0 VSS__t364 nfet_03v3 L=0.28U W=0.24U
+ AS=0.1684P AD=0.1022P PS=1.72U PD=0.96U
* device instance $434 r0 *1 485.79,1.77 nfet
X$434 BLB108__t0 WL0__t35 \$112__t4 VSS__t492 nfet_03v3 L=0.28U W=0.24U
+ AS=0.1022P AD=0.1684P PS=0.96U PD=1.72U
* device instance $435 r0 *1 483.75,1.83 nfet
X$435 VSS__t25 \$112__t2 \$457__t4 VSS__t620 nfet_03v3 L=0.28U W=0.36U
+ AS=0.1022P AD=0.169P PS=0.96U PD=1.28U
* device instance $436 r0 *1 484.93,1.83 nfet
X$436 \$112__t3 \$457__t2 VSS__t144 VSS__t748 nfet_03v3 L=0.28U W=0.36U
+ AS=0.169P AD=0.1022P PS=1.28U PD=0.96U
* device instance $437 r0 *1 487.35,1.77 nfet
X$437 \$460__t3 WL0__t197 BL109__t0 VSS__t365 nfet_03v3 L=0.28U W=0.24U
+ AS=0.1684P AD=0.1022P PS=1.72U PD=0.96U
* device instance $438 r0 *1 490.25,1.77 nfet
X$438 BLB109__t0 WL0__t33 \$113__t4 VSS__t493 nfet_03v3 L=0.28U W=0.24U
+ AS=0.1022P AD=0.1684P PS=0.96U PD=1.72U
* device instance $439 r0 *1 488.21,1.83 nfet
X$439 VSS__t18 \$113__t2 \$460__t4 VSS__t621 nfet_03v3 L=0.28U W=0.36U
+ AS=0.1022P AD=0.169P PS=0.96U PD=1.28U
* device instance $440 r0 *1 489.39,1.83 nfet
X$440 \$113__t3 \$460__t2 VSS__t143 VSS__t749 nfet_03v3 L=0.28U W=0.36U
+ AS=0.169P AD=0.1022P PS=1.28U PD=0.96U
* device instance $441 r0 *1 491.81,1.77 nfet
X$441 \$463__t3 WL0__t195 BL110__t0 VSS__t366 nfet_03v3 L=0.28U W=0.24U
+ AS=0.1684P AD=0.1022P PS=1.72U PD=0.96U
* device instance $442 r0 *1 494.71,1.77 nfet
X$442 BLB110__t0 WL0__t30 \$114__t4 VSS__t494 nfet_03v3 L=0.28U W=0.24U
+ AS=0.1022P AD=0.1684P PS=0.96U PD=1.72U
* device instance $443 r0 *1 492.67,1.83 nfet
X$443 VSS__t24 \$114__t2 \$463__t4 VSS__t622 nfet_03v3 L=0.28U W=0.36U
+ AS=0.1022P AD=0.169P PS=0.96U PD=1.28U
* device instance $444 r0 *1 493.85,1.83 nfet
X$444 \$114__t3 \$463__t2 VSS__t142 VSS__t750 nfet_03v3 L=0.28U W=0.36U
+ AS=0.169P AD=0.1022P PS=1.28U PD=0.96U
* device instance $445 r0 *1 496.27,1.77 nfet
X$445 \$466__t3 WL0__t191 BL111__t0 VSS__t367 nfet_03v3 L=0.28U W=0.24U
+ AS=0.1684P AD=0.1022P PS=1.72U PD=0.96U
* device instance $446 r0 *1 499.17,1.77 nfet
X$446 BLB111__t0 WL0__t27 \$115__t4 VSS__t495 nfet_03v3 L=0.28U W=0.24U
+ AS=0.1022P AD=0.1684P PS=0.96U PD=1.72U
* device instance $447 r0 *1 497.13,1.83 nfet
X$447 VSS__t27 \$115__t2 \$466__t4 VSS__t623 nfet_03v3 L=0.28U W=0.36U
+ AS=0.1022P AD=0.169P PS=0.96U PD=1.28U
* device instance $448 r0 *1 498.31,1.83 nfet
X$448 \$115__t3 \$466__t2 VSS__t141 VSS__t751 nfet_03v3 L=0.28U W=0.36U
+ AS=0.169P AD=0.1022P PS=1.28U PD=0.96U
* device instance $449 r0 *1 500.73,1.77 nfet
X$449 \$469__t3 WL0__t168 BL112__t0 VSS__t368 nfet_03v3 L=0.28U W=0.24U
+ AS=0.1684P AD=0.1022P PS=1.72U PD=0.96U
* device instance $450 r0 *1 503.63,1.77 nfet
X$450 BLB112__t0 WL0__t66 \$116__t4 VSS__t496 nfet_03v3 L=0.28U W=0.24U
+ AS=0.1022P AD=0.1684P PS=0.96U PD=1.72U
* device instance $451 r0 *1 501.59,1.83 nfet
X$451 VSS__t52 \$116__t2 \$469__t4 VSS__t624 nfet_03v3 L=0.28U W=0.36U
+ AS=0.1022P AD=0.169P PS=0.96U PD=1.28U
* device instance $452 r0 *1 502.77,1.83 nfet
X$452 \$116__t3 \$469__t2 VSS__t164 VSS__t752 nfet_03v3 L=0.28U W=0.36U
+ AS=0.169P AD=0.1022P PS=1.28U PD=0.96U
* device instance $453 r0 *1 505.19,1.77 nfet
X$453 \$472__t3 WL0__t167 BL113__t0 VSS__t369 nfet_03v3 L=0.28U W=0.24U
+ AS=0.1684P AD=0.1022P PS=1.72U PD=0.96U
* device instance $454 r0 *1 508.09,1.77 nfet
X$454 BLB113__t0 WL0__t18 \$117__t4 VSS__t497 nfet_03v3 L=0.28U W=0.24U
+ AS=0.1022P AD=0.1684P PS=0.96U PD=1.72U
* device instance $455 r0 *1 506.05,1.83 nfet
X$455 VSS__t55 \$117__t2 \$472__t4 VSS__t625 nfet_03v3 L=0.28U W=0.36U
+ AS=0.1022P AD=0.169P PS=0.96U PD=1.28U
* device instance $456 r0 *1 507.23,1.83 nfet
X$456 \$117__t3 \$472__t2 VSS__t163 VSS__t753 nfet_03v3 L=0.28U W=0.36U
+ AS=0.169P AD=0.1022P PS=1.28U PD=0.96U
* device instance $457 r0 *1 509.65,1.77 nfet
X$457 \$475__t3 WL0__t164 BL114__t0 VSS__t370 nfet_03v3 L=0.28U W=0.24U
+ AS=0.1684P AD=0.1022P PS=1.72U PD=0.96U
* device instance $458 r0 *1 512.55,1.77 nfet
X$458 BLB114__t0 WL0__t12 \$118__t4 VSS__t498 nfet_03v3 L=0.28U W=0.24U
+ AS=0.1022P AD=0.1684P PS=0.96U PD=1.72U
* device instance $459 r0 *1 510.51,1.83 nfet
X$459 VSS__t64 \$118__t2 \$475__t4 VSS__t626 nfet_03v3 L=0.28U W=0.36U
+ AS=0.1022P AD=0.169P PS=0.96U PD=1.28U
* device instance $460 r0 *1 511.69,1.83 nfet
X$460 \$118__t3 \$475__t2 VSS__t162 VSS__t754 nfet_03v3 L=0.28U W=0.36U
+ AS=0.169P AD=0.1022P PS=1.28U PD=0.96U
* device instance $461 r0 *1 514.11,1.77 nfet
X$461 \$478__t3 WL0__t160 BL115__t0 VSS__t371 nfet_03v3 L=0.28U W=0.24U
+ AS=0.1684P AD=0.1022P PS=1.72U PD=0.96U
* device instance $462 r0 *1 517.01,1.77 nfet
X$462 BLB115__t0 WL0__t49 \$119__t4 VSS__t499 nfet_03v3 L=0.28U W=0.24U
+ AS=0.1022P AD=0.1684P PS=0.96U PD=1.72U
* device instance $463 r0 *1 514.97,1.83 nfet
X$463 VSS__t15 \$119__t2 \$478__t4 VSS__t627 nfet_03v3 L=0.28U W=0.36U
+ AS=0.1022P AD=0.169P PS=0.96U PD=1.28U
* device instance $464 r0 *1 516.15,1.83 nfet
X$464 \$119__t3 \$478__t2 VSS__t161 VSS__t755 nfet_03v3 L=0.28U W=0.36U
+ AS=0.169P AD=0.1022P PS=1.28U PD=0.96U
* device instance $465 r0 *1 518.57,1.77 nfet
X$465 \$481__t3 WL0__t157 BL116__t0 VSS__t372 nfet_03v3 L=0.28U W=0.24U
+ AS=0.1684P AD=0.1022P PS=1.72U PD=0.96U
* device instance $466 r0 *1 521.47,1.77 nfet
X$466 BLB116__t0 WL0__t53 \$120__t4 VSS__t500 nfet_03v3 L=0.28U W=0.24U
+ AS=0.1022P AD=0.1684P PS=0.96U PD=1.72U
* device instance $467 r0 *1 519.43,1.83 nfet
X$467 VSS__t7 \$120__t2 \$481__t4 VSS__t628 nfet_03v3 L=0.28U W=0.36U
+ AS=0.1022P AD=0.169P PS=0.96U PD=1.28U
* device instance $468 r0 *1 520.61,1.83 nfet
X$468 \$120__t3 \$481__t2 VSS__t160 VSS__t756 nfet_03v3 L=0.28U W=0.36U
+ AS=0.169P AD=0.1022P PS=1.28U PD=0.96U
* device instance $469 r0 *1 523.03,1.77 nfet
X$469 \$484__t3 WL0__t179 BL117__t0 VSS__t373 nfet_03v3 L=0.28U W=0.24U
+ AS=0.1684P AD=0.1022P PS=1.72U PD=0.96U
* device instance $470 r0 *1 525.93,1.77 nfet
X$470 BLB117__t0 WL0__t26 \$121__t4 VSS__t501 nfet_03v3 L=0.28U W=0.24U
+ AS=0.1022P AD=0.1684P PS=0.96U PD=1.72U
* device instance $471 r0 *1 523.89,1.83 nfet
X$471 VSS__t45 \$121__t2 \$484__t4 VSS__t629 nfet_03v3 L=0.28U W=0.36U
+ AS=0.1022P AD=0.169P PS=0.96U PD=1.28U
* device instance $472 r0 *1 525.07,1.83 nfet
X$472 \$121__t3 \$484__t2 VSS__t159 VSS__t757 nfet_03v3 L=0.28U W=0.36U
+ AS=0.169P AD=0.1022P PS=1.28U PD=0.96U
* device instance $473 r0 *1 527.49,1.77 nfet
X$473 \$487__t3 WL0__t184 BL118__t0 VSS__t374 nfet_03v3 L=0.28U W=0.24U
+ AS=0.1684P AD=0.1022P PS=1.72U PD=0.96U
* device instance $474 r0 *1 530.39,1.77 nfet
X$474 BLB118__t0 WL0__t39 \$122__t4 VSS__t502 nfet_03v3 L=0.28U W=0.24U
+ AS=0.1022P AD=0.1684P PS=0.96U PD=1.72U
* device instance $475 r0 *1 528.35,1.83 nfet
X$475 VSS__t124 \$122__t2 \$487__t4 VSS__t630 nfet_03v3 L=0.28U W=0.36U
+ AS=0.1022P AD=0.169P PS=0.96U PD=1.28U
* device instance $476 r0 *1 529.53,1.83 nfet
X$476 \$122__t3 \$487__t2 VSS__t158 VSS__t758 nfet_03v3 L=0.28U W=0.36U
+ AS=0.169P AD=0.1022P PS=1.28U PD=0.96U
* device instance $477 r0 *1 531.95,1.77 nfet
X$477 \$490__t3 WL0__t180 BL119__t0 VSS__t375 nfet_03v3 L=0.28U W=0.24U
+ AS=0.1684P AD=0.1022P PS=1.72U PD=0.96U
* device instance $478 r0 *1 534.85,1.77 nfet
X$478 BLB119__t0 WL0__t55 \$123__t4 VSS__t503 nfet_03v3 L=0.28U W=0.24U
+ AS=0.1022P AD=0.1684P PS=0.96U PD=1.72U
* device instance $479 r0 *1 532.81,1.83 nfet
X$479 VSS__t94 \$123__t2 \$490__t4 VSS__t631 nfet_03v3 L=0.28U W=0.36U
+ AS=0.1022P AD=0.169P PS=0.96U PD=1.28U
* device instance $480 r0 *1 533.99,1.83 nfet
X$480 \$123__t3 \$490__t2 VSS__t157 VSS__t759 nfet_03v3 L=0.28U W=0.36U
+ AS=0.169P AD=0.1022P PS=1.28U PD=0.96U
* device instance $481 r0 *1 536.41,1.77 nfet
X$481 \$493__t3 WL0__t177 BL120__t0 VSS__t376 nfet_03v3 L=0.28U W=0.24U
+ AS=0.1684P AD=0.1022P PS=1.72U PD=0.96U
* device instance $482 r0 *1 539.31,1.77 nfet
X$482 BLB120__t0 WL0__t43 \$124__t4 VSS__t504 nfet_03v3 L=0.28U W=0.24U
+ AS=0.1022P AD=0.1684P PS=0.96U PD=1.72U
* device instance $483 r0 *1 537.27,1.83 nfet
X$483 VSS__t102 \$124__t2 \$493__t4 VSS__t632 nfet_03v3 L=0.28U W=0.36U
+ AS=0.1022P AD=0.169P PS=0.96U PD=1.28U
* device instance $484 r0 *1 538.45,1.83 nfet
X$484 \$124__t3 \$493__t2 VSS__t156 VSS__t760 nfet_03v3 L=0.28U W=0.36U
+ AS=0.169P AD=0.1022P PS=1.28U PD=0.96U
* device instance $485 r0 *1 540.87,1.77 nfet
X$485 \$496__t3 WL0__t173 BL121__t0 VSS__t377 nfet_03v3 L=0.28U W=0.24U
+ AS=0.1684P AD=0.1022P PS=1.72U PD=0.96U
* device instance $486 r0 *1 543.77,1.77 nfet
X$486 BLB121__t0 WL0__t14 \$125__t4 VSS__t505 nfet_03v3 L=0.28U W=0.24U
+ AS=0.1022P AD=0.1684P PS=0.96U PD=1.72U
* device instance $487 r0 *1 541.73,1.83 nfet
X$487 VSS__t79 \$125__t2 \$496__t4 VSS__t633 nfet_03v3 L=0.28U W=0.36U
+ AS=0.1022P AD=0.169P PS=0.96U PD=1.28U
* device instance $488 r0 *1 542.91,1.83 nfet
X$488 \$125__t3 \$496__t2 VSS__t155 VSS__t761 nfet_03v3 L=0.28U W=0.36U
+ AS=0.169P AD=0.1022P PS=1.28U PD=0.96U
* device instance $489 r0 *1 545.33,1.77 nfet
X$489 \$499__t3 WL0__t134 BL122__t0 VSS__t378 nfet_03v3 L=0.28U W=0.24U
+ AS=0.1684P AD=0.1022P PS=1.72U PD=0.96U
* device instance $490 r0 *1 548.23,1.77 nfet
X$490 BLB122__t0 WL0__t2 \$126__t4 VSS__t506 nfet_03v3 L=0.28U W=0.24U
+ AS=0.1022P AD=0.1684P PS=0.96U PD=1.72U
* device instance $491 r0 *1 546.19,1.83 nfet
X$491 VSS__t108 \$126__t2 \$499__t4 VSS__t634 nfet_03v3 L=0.28U W=0.36U
+ AS=0.1022P AD=0.169P PS=0.96U PD=1.28U
* device instance $492 r0 *1 547.37,1.83 nfet
X$492 \$126__t3 \$499__t2 VSS__t154 VSS__t762 nfet_03v3 L=0.28U W=0.36U
+ AS=0.169P AD=0.1022P PS=1.28U PD=0.96U
* device instance $493 r0 *1 549.79,1.77 nfet
X$493 \$502__t3 WL0__t131 BL123__t0 VSS__t379 nfet_03v3 L=0.28U W=0.24U
+ AS=0.1684P AD=0.1022P PS=1.72U PD=0.96U
* device instance $494 r0 *1 552.69,1.77 nfet
X$494 BLB123__t0 WL0__t16 \$127__t4 VSS__t507 nfet_03v3 L=0.28U W=0.24U
+ AS=0.1022P AD=0.1684P PS=0.96U PD=1.72U
* device instance $495 r0 *1 550.65,1.83 nfet
X$495 VSS__t117 \$127__t2 \$502__t4 VSS__t635 nfet_03v3 L=0.28U W=0.36U
+ AS=0.1022P AD=0.169P PS=0.96U PD=1.28U
* device instance $496 r0 *1 551.83,1.83 nfet
X$496 \$127__t3 \$502__t2 VSS__t153 VSS__t763 nfet_03v3 L=0.28U W=0.36U
+ AS=0.169P AD=0.1022P PS=1.28U PD=0.96U
* device instance $497 r0 *1 554.25,1.77 nfet
X$497 \$505__t3 WL0__t138 BL124__t0 VSS__t380 nfet_03v3 L=0.28U W=0.24U
+ AS=0.1684P AD=0.1022P PS=1.72U PD=0.96U
* device instance $498 r0 *1 557.15,1.77 nfet
X$498 BLB124__t0 WL0__t17 \$128__t4 VSS__t508 nfet_03v3 L=0.28U W=0.24U
+ AS=0.1022P AD=0.1684P PS=0.96U PD=1.72U
* device instance $499 r0 *1 555.11,1.83 nfet
X$499 VSS__t121 \$128__t2 \$505__t4 VSS__t636 nfet_03v3 L=0.28U W=0.36U
+ AS=0.1022P AD=0.169P PS=0.96U PD=1.28U
* device instance $500 r0 *1 556.29,1.83 nfet
X$500 \$128__t3 \$505__t2 VSS__t152 VSS__t764 nfet_03v3 L=0.28U W=0.36U
+ AS=0.169P AD=0.1022P PS=1.28U PD=0.96U
* device instance $501 r0 *1 558.71,1.77 nfet
X$501 \$508__t3 WL0__t142 BL125__t0 VSS__t381 nfet_03v3 L=0.28U W=0.24U
+ AS=0.1684P AD=0.1022P PS=1.72U PD=0.96U
* device instance $502 r0 *1 561.61,1.77 nfet
X$502 BLB125__t0 WL0__t20 \$129__t4 VSS__t509 nfet_03v3 L=0.28U W=0.24U
+ AS=0.1022P AD=0.1684P PS=0.96U PD=1.72U
* device instance $503 r0 *1 559.57,1.83 nfet
X$503 VSS__t83 \$129__t2 \$508__t4 VSS__t637 nfet_03v3 L=0.28U W=0.36U
+ AS=0.1022P AD=0.169P PS=0.96U PD=1.28U
* device instance $504 r0 *1 560.75,1.83 nfet
X$504 \$129__t3 \$508__t2 VSS__t151 VSS__t765 nfet_03v3 L=0.28U W=0.36U
+ AS=0.169P AD=0.1022P PS=1.28U PD=0.96U
* device instance $505 r0 *1 563.17,1.77 nfet
X$505 \$511__t3 WL0__t147 BL126__t0 VSS__t382 nfet_03v3 L=0.28U W=0.24U
+ AS=0.1684P AD=0.1022P PS=1.72U PD=0.96U
* device instance $506 r0 *1 566.07,1.77 nfet
X$506 BLB126__t0 WL0__t13 \$130__t4 VSS__t510 nfet_03v3 L=0.28U W=0.24U
+ AS=0.1022P AD=0.1684P PS=0.96U PD=1.72U
* device instance $507 r0 *1 564.03,1.83 nfet
X$507 VSS__t92 \$130__t2 \$511__t4 VSS__t638 nfet_03v3 L=0.28U W=0.36U
+ AS=0.1022P AD=0.169P PS=0.96U PD=1.28U
* device instance $508 r0 *1 565.21,1.83 nfet
X$508 \$130__t3 \$511__t2 VSS__t150 VSS__t766 nfet_03v3 L=0.28U W=0.36U
+ AS=0.169P AD=0.1022P PS=1.28U PD=0.96U
* device instance $509 r0 *1 567.63,1.77 nfet
X$509 \$514__t3 WL0__t152 BL127__t0 VSS__t383 nfet_03v3 L=0.28U W=0.24U
+ AS=0.1684P AD=0.1022P PS=1.72U PD=0.96U
* device instance $510 r0 *1 570.53,1.77 nfet
X$510 BLB127__t0 WL0__t3 \$131__t4 VSS__t511 nfet_03v3 L=0.28U W=0.24U
+ AS=0.1022P AD=0.1684P PS=0.96U PD=1.72U
* device instance $511 r0 *1 568.49,1.83 nfet
X$511 VSS__t103 \$131__t2 \$514__t4 VSS__t639 nfet_03v3 L=0.28U W=0.36U
+ AS=0.1022P AD=0.169P PS=0.96U PD=1.28U
* device instance $512 r0 *1 569.67,1.83 nfet
X$512 \$131__t3 \$514__t2 VSS__t165 VSS__t767 nfet_03v3 L=0.28U W=0.36U
+ AS=0.169P AD=0.1022P PS=1.28U PD=0.96U
* device instance $513 r0 *1 2.07,3.72 pfet
X$513 VDD__t257 \$4__t1 \$133__t1 VDD__t0 pfet_03v3 L=0.28U W=0.22U AS=0.1664P
+ AD=0.155P PS=1.72U PD=1.28U
* device instance $514 r0 *1 3.25,3.72 pfet
X$514 \$4__t2 \$133__t2 VDD__t256 VDD__t1 pfet_03v3 L=0.28U W=0.22U AS=0.155P
+ AD=0.1664P PS=1.28U PD=1.72U
* device instance $515 r0 *1 6.53,3.72 pfet
X$515 VDD__t309 \$5__t1 \$136__t1 VDD__t180 pfet_03v3 L=0.28U W=0.22U
+ AS=0.1664P AD=0.155P PS=1.72U PD=1.28U
* device instance $516 r0 *1 7.71,3.72 pfet
X$516 \$5__t0 \$136__t0 VDD__t501 VDD__t118 pfet_03v3 L=0.28U W=0.22U AS=0.155P
+ AD=0.1664P PS=1.28U PD=1.72U
* device instance $517 r0 *1 10.99,3.72 pfet
X$517 VDD__t308 \$6__t1 \$139__t1 VDD__t179 pfet_03v3 L=0.28U W=0.22U
+ AS=0.1664P AD=0.155P PS=1.72U PD=1.28U
* device instance $518 r0 *1 12.17,3.72 pfet
X$518 \$6__t0 \$139__t0 VDD__t504 VDD__t121 pfet_03v3 L=0.28U W=0.22U AS=0.155P
+ AD=0.1664P PS=1.28U PD=1.72U
* device instance $519 r0 *1 15.45,3.72 pfet
X$519 VDD__t307 \$7__t1 \$142__t1 VDD__t178 pfet_03v3 L=0.28U W=0.22U
+ AS=0.1664P AD=0.155P PS=1.72U PD=1.28U
* device instance $520 r0 *1 16.63,3.72 pfet
X$520 \$7__t0 \$142__t0 VDD__t506 VDD__t123 pfet_03v3 L=0.28U W=0.22U AS=0.155P
+ AD=0.1664P PS=1.28U PD=1.72U
* device instance $521 r0 *1 19.91,3.72 pfet
X$521 VDD__t306 \$8__t1 \$145__t1 VDD__t177 pfet_03v3 L=0.28U W=0.22U
+ AS=0.1664P AD=0.155P PS=1.72U PD=1.28U
* device instance $522 r0 *1 21.09,3.72 pfet
X$522 \$8__t0 \$145__t0 VDD__t509 VDD__t126 pfet_03v3 L=0.28U W=0.22U AS=0.155P
+ AD=0.1664P PS=1.28U PD=1.72U
* device instance $523 r0 *1 24.37,3.72 pfet
X$523 VDD__t305 \$9__t1 \$148__t1 VDD__t176 pfet_03v3 L=0.28U W=0.22U
+ AS=0.1664P AD=0.155P PS=1.72U PD=1.28U
* device instance $524 r0 *1 25.55,3.72 pfet
X$524 \$9__t0 \$148__t0 VDD__t459 VDD__t76 pfet_03v3 L=0.28U W=0.22U AS=0.155P
+ AD=0.1664P PS=1.28U PD=1.72U
* device instance $525 r0 *1 28.83,3.72 pfet
X$525 VDD__t304 \$10__t1 \$151__t1 VDD__t175 pfet_03v3 L=0.28U W=0.22U
+ AS=0.1664P AD=0.155P PS=1.72U PD=1.28U
* device instance $526 r0 *1 30.01,3.72 pfet
X$526 \$10__t0 \$151__t0 VDD__t461 VDD__t78 pfet_03v3 L=0.28U W=0.22U AS=0.155P
+ AD=0.1664P PS=1.28U PD=1.72U
* device instance $527 r0 *1 33.29,3.72 pfet
X$527 VDD__t303 \$11__t1 \$154__t1 VDD__t174 pfet_03v3 L=0.28U W=0.22U
+ AS=0.1664P AD=0.155P PS=1.72U PD=1.28U
* device instance $528 r0 *1 34.47,3.72 pfet
X$528 \$11__t0 \$154__t0 VDD__t464 VDD__t81 pfet_03v3 L=0.28U W=0.22U AS=0.155P
+ AD=0.1664P PS=1.28U PD=1.72U
* device instance $529 r0 *1 37.75,3.72 pfet
X$529 VDD__t331 \$12__t1 \$157__t1 VDD__t202 pfet_03v3 L=0.28U W=0.22U
+ AS=0.1664P AD=0.155P PS=1.72U PD=1.28U
* device instance $530 r0 *1 38.93,3.72 pfet
X$530 \$12__t0 \$157__t0 VDD__t467 VDD__t84 pfet_03v3 L=0.28U W=0.22U AS=0.155P
+ AD=0.1664P PS=1.28U PD=1.72U
* device instance $531 r0 *1 42.21,3.72 pfet
X$531 VDD__t341 \$13__t1 \$160__t1 VDD__t212 pfet_03v3 L=0.28U W=0.22U
+ AS=0.1664P AD=0.155P PS=1.72U PD=1.28U
* device instance $532 r0 *1 43.39,3.72 pfet
X$532 \$13__t0 \$160__t0 VDD__t469 VDD__t86 pfet_03v3 L=0.28U W=0.22U AS=0.155P
+ AD=0.1664P PS=1.28U PD=1.72U
* device instance $533 r0 *1 46.67,3.72 pfet
X$533 VDD__t340 \$14__t1 \$163__t1 VDD__t211 pfet_03v3 L=0.28U W=0.22U
+ AS=0.1664P AD=0.155P PS=1.72U PD=1.28U
* device instance $534 r0 *1 47.85,3.72 pfet
X$534 \$14__t0 \$163__t0 VDD__t472 VDD__t89 pfet_03v3 L=0.28U W=0.22U AS=0.155P
+ AD=0.1664P PS=1.28U PD=1.72U
* device instance $535 r0 *1 51.13,3.72 pfet
X$535 VDD__t339 \$15__t1 \$166__t1 VDD__t210 pfet_03v3 L=0.28U W=0.22U
+ AS=0.1664P AD=0.155P PS=1.72U PD=1.28U
* device instance $536 r0 *1 52.31,3.72 pfet
X$536 \$15__t0 \$166__t0 VDD__t475 VDD__t92 pfet_03v3 L=0.28U W=0.22U AS=0.155P
+ AD=0.1664P PS=1.28U PD=1.72U
* device instance $537 r0 *1 55.59,3.72 pfet
X$537 VDD__t338 \$16__t1 \$169__t1 VDD__t209 pfet_03v3 L=0.28U W=0.22U
+ AS=0.1664P AD=0.155P PS=1.72U PD=1.28U
* device instance $538 r0 *1 56.77,3.72 pfet
X$538 \$16__t0 \$169__t0 VDD__t477 VDD__t94 pfet_03v3 L=0.28U W=0.22U AS=0.155P
+ AD=0.1664P PS=1.28U PD=1.72U
* device instance $539 r0 *1 60.05,3.72 pfet
X$539 VDD__t337 \$17__t1 \$172__t1 VDD__t208 pfet_03v3 L=0.28U W=0.22U
+ AS=0.1664P AD=0.155P PS=1.72U PD=1.28U
* device instance $540 r0 *1 61.23,3.72 pfet
X$540 \$17__t0 \$172__t0 VDD__t481 VDD__t98 pfet_03v3 L=0.28U W=0.22U AS=0.155P
+ AD=0.1664P PS=1.28U PD=1.72U
* device instance $541 r0 *1 64.51,3.72 pfet
X$541 VDD__t336 \$18__t1 \$175__t1 VDD__t207 pfet_03v3 L=0.28U W=0.22U
+ AS=0.1664P AD=0.155P PS=1.72U PD=1.28U
* device instance $542 r0 *1 65.69,3.72 pfet
X$542 \$18__t0 \$175__t0 VDD__t483 VDD__t100 pfet_03v3 L=0.28U W=0.22U
+ AS=0.155P AD=0.1664P PS=1.28U PD=1.72U
* device instance $543 r0 *1 68.97,3.72 pfet
X$543 VDD__t335 \$19__t1 \$178__t1 VDD__t206 pfet_03v3 L=0.28U W=0.22U
+ AS=0.1664P AD=0.155P PS=1.72U PD=1.28U
* device instance $544 r0 *1 70.15,3.72 pfet
X$544 \$19__t0 \$178__t0 VDD__t484 VDD__t101 pfet_03v3 L=0.28U W=0.22U
+ AS=0.155P AD=0.1664P PS=1.28U PD=1.72U
* device instance $545 r0 *1 73.43,3.72 pfet
X$545 VDD__t384 \$20__t1 \$181__t1 VDD__t255 pfet_03v3 L=0.28U W=0.22U
+ AS=0.1664P AD=0.155P PS=1.72U PD=1.28U
* device instance $546 r0 *1 74.61,3.72 pfet
X$546 \$20__t0 \$181__t0 VDD__t441 VDD__t58 pfet_03v3 L=0.28U W=0.22U AS=0.155P
+ AD=0.1664P PS=1.28U PD=1.72U
* device instance $547 r0 *1 77.89,3.72 pfet
X$547 VDD__t382 \$21__t1 \$184__t1 VDD__t253 pfet_03v3 L=0.28U W=0.22U
+ AS=0.1664P AD=0.155P PS=1.72U PD=1.28U
* device instance $548 r0 *1 79.07,3.72 pfet
X$548 \$21__t0 \$184__t0 VDD__t430 VDD__t47 pfet_03v3 L=0.28U W=0.22U AS=0.155P
+ AD=0.1664P PS=1.28U PD=1.72U
* device instance $549 r0 *1 82.35,3.72 pfet
X$549 VDD__t381 \$22__t1 \$187__t1 VDD__t252 pfet_03v3 L=0.28U W=0.22U
+ AS=0.1664P AD=0.155P PS=1.72U PD=1.28U
* device instance $550 r0 *1 83.53,3.72 pfet
X$550 \$22__t0 \$187__t0 VDD__t401 VDD__t18 pfet_03v3 L=0.28U W=0.22U AS=0.155P
+ AD=0.1664P PS=1.28U PD=1.72U
* device instance $551 r0 *1 86.81,3.72 pfet
X$551 VDD__t380 \$23__t1 \$190__t1 VDD__t251 pfet_03v3 L=0.28U W=0.22U
+ AS=0.1664P AD=0.155P PS=1.72U PD=1.28U
* device instance $552 r0 *1 87.99,3.72 pfet
X$552 \$23__t0 \$190__t0 VDD__t400 VDD__t17 pfet_03v3 L=0.28U W=0.22U AS=0.155P
+ AD=0.1664P PS=1.28U PD=1.72U
* device instance $553 r0 *1 91.27,3.72 pfet
X$553 VDD__t379 \$24__t1 \$193__t1 VDD__t250 pfet_03v3 L=0.28U W=0.22U
+ AS=0.1664P AD=0.155P PS=1.72U PD=1.28U
* device instance $554 r0 *1 92.45,3.72 pfet
X$554 \$24__t0 \$193__t0 VDD__t398 VDD__t15 pfet_03v3 L=0.28U W=0.22U AS=0.155P
+ AD=0.1664P PS=1.28U PD=1.72U
* device instance $555 r0 *1 95.73,3.72 pfet
X$555 VDD__t378 \$25__t1 \$196__t1 VDD__t249 pfet_03v3 L=0.28U W=0.22U
+ AS=0.1664P AD=0.155P PS=1.72U PD=1.28U
* device instance $556 r0 *1 96.91,3.72 pfet
X$556 \$25__t0 \$196__t0 VDD__t397 VDD__t14 pfet_03v3 L=0.28U W=0.22U AS=0.155P
+ AD=0.1664P PS=1.28U PD=1.72U
* device instance $557 r0 *1 100.19,3.72 pfet
X$557 VDD__t377 \$26__t1 \$199__t1 VDD__t248 pfet_03v3 L=0.28U W=0.22U
+ AS=0.1664P AD=0.155P PS=1.72U PD=1.28U
* device instance $558 r0 *1 101.37,3.72 pfet
X$558 \$26__t0 \$199__t0 VDD__t395 VDD__t12 pfet_03v3 L=0.28U W=0.22U AS=0.155P
+ AD=0.1664P PS=1.28U PD=1.72U
* device instance $559 r0 *1 104.65,3.72 pfet
X$559 VDD__t376 \$27__t1 \$202__t1 VDD__t247 pfet_03v3 L=0.28U W=0.22U
+ AS=0.1664P AD=0.155P PS=1.72U PD=1.28U
* device instance $560 r0 *1 105.83,3.72 pfet
X$560 \$27__t0 \$202__t0 VDD__t394 VDD__t11 pfet_03v3 L=0.28U W=0.22U AS=0.155P
+ AD=0.1664P PS=1.28U PD=1.72U
* device instance $561 r0 *1 109.11,3.72 pfet
X$561 VDD__t375 \$28__t1 \$205__t1 VDD__t246 pfet_03v3 L=0.28U W=0.22U
+ AS=0.1664P AD=0.155P PS=1.72U PD=1.28U
* device instance $562 r0 *1 110.29,3.72 pfet
X$562 \$28__t0 \$205__t0 VDD__t392 VDD__t9 pfet_03v3 L=0.28U W=0.22U AS=0.155P
+ AD=0.1664P PS=1.28U PD=1.72U
* device instance $563 r0 *1 113.57,3.72 pfet
X$563 VDD__t374 \$29__t1 \$208__t1 VDD__t245 pfet_03v3 L=0.28U W=0.22U
+ AS=0.1664P AD=0.155P PS=1.72U PD=1.28U
* device instance $564 r0 *1 114.75,3.72 pfet
X$564 \$29__t0 \$208__t0 VDD__t391 VDD__t8 pfet_03v3 L=0.28U W=0.22U AS=0.155P
+ AD=0.1664P PS=1.28U PD=1.72U
* device instance $565 r0 *1 118.03,3.72 pfet
X$565 VDD__t373 \$30__t1 \$211__t1 VDD__t244 pfet_03v3 L=0.28U W=0.22U
+ AS=0.1664P AD=0.155P PS=1.72U PD=1.28U
* device instance $566 r0 *1 119.21,3.72 pfet
X$566 \$30__t0 \$211__t0 VDD__t389 VDD__t6 pfet_03v3 L=0.28U W=0.22U AS=0.155P
+ AD=0.1664P PS=1.28U PD=1.72U
* device instance $567 r0 *1 122.49,3.72 pfet
X$567 VDD__t372 \$31__t1 \$214__t1 VDD__t243 pfet_03v3 L=0.28U W=0.22U
+ AS=0.1664P AD=0.155P PS=1.72U PD=1.28U
* device instance $568 r0 *1 123.67,3.72 pfet
X$568 \$31__t0 \$214__t0 VDD__t388 VDD__t5 pfet_03v3 L=0.28U W=0.22U AS=0.155P
+ AD=0.1664P PS=1.28U PD=1.72U
* device instance $569 r0 *1 126.95,3.72 pfet
X$569 VDD__t371 \$32__t1 \$217__t1 VDD__t242 pfet_03v3 L=0.28U W=0.22U
+ AS=0.1664P AD=0.155P PS=1.72U PD=1.28U
* device instance $570 r0 *1 128.13,3.72 pfet
X$570 \$32__t0 \$217__t0 VDD__t386 VDD__t3 pfet_03v3 L=0.28U W=0.22U AS=0.155P
+ AD=0.1664P PS=1.28U PD=1.72U
* device instance $571 r0 *1 131.41,3.72 pfet
X$571 VDD__t370 \$33__t1 \$220__t1 VDD__t241 pfet_03v3 L=0.28U W=0.22U
+ AS=0.1664P AD=0.155P PS=1.72U PD=1.28U
* device instance $572 r0 *1 132.59,3.72 pfet
X$572 \$33__t0 \$220__t0 VDD__t385 VDD__t2 pfet_03v3 L=0.28U W=0.22U AS=0.155P
+ AD=0.1664P PS=1.28U PD=1.72U
* device instance $573 r0 *1 135.87,3.72 pfet
X$573 VDD__t369 \$34__t1 \$223__t1 VDD__t240 pfet_03v3 L=0.28U W=0.22U
+ AS=0.1664P AD=0.155P PS=1.72U PD=1.28U
* device instance $574 r0 *1 137.05,3.72 pfet
X$574 \$34__t0 \$223__t0 VDD__t420 VDD__t37 pfet_03v3 L=0.28U W=0.22U AS=0.155P
+ AD=0.1664P PS=1.28U PD=1.72U
* device instance $575 r0 *1 140.33,3.72 pfet
X$575 VDD__t368 \$35__t1 \$226__t1 VDD__t239 pfet_03v3 L=0.28U W=0.22U
+ AS=0.1664P AD=0.155P PS=1.72U PD=1.28U
* device instance $576 r0 *1 141.51,3.72 pfet
X$576 \$35__t0 \$226__t0 VDD__t419 VDD__t36 pfet_03v3 L=0.28U W=0.22U AS=0.155P
+ AD=0.1664P PS=1.28U PD=1.72U
* device instance $577 r0 *1 144.79,3.72 pfet
X$577 VDD__t294 \$36__t1 \$229__t1 VDD__t165 pfet_03v3 L=0.28U W=0.22U
+ AS=0.1664P AD=0.155P PS=1.72U PD=1.28U
* device instance $578 r0 *1 145.97,3.72 pfet
X$578 \$36__t0 \$229__t0 VDD__t399 VDD__t16 pfet_03v3 L=0.28U W=0.22U AS=0.155P
+ AD=0.1664P PS=1.28U PD=1.72U
* device instance $579 r0 *1 149.25,3.72 pfet
X$579 VDD__t292 \$37__t1 \$232__t1 VDD__t163 pfet_03v3 L=0.28U W=0.22U
+ AS=0.1664P AD=0.155P PS=1.72U PD=1.28U
* device instance $580 r0 *1 150.43,3.72 pfet
X$580 \$37__t0 \$232__t0 VDD__t396 VDD__t13 pfet_03v3 L=0.28U W=0.22U AS=0.155P
+ AD=0.1664P PS=1.28U PD=1.72U
* device instance $581 r0 *1 153.71,3.72 pfet
X$581 VDD__t290 \$38__t1 \$235__t1 VDD__t161 pfet_03v3 L=0.28U W=0.22U
+ AS=0.1664P AD=0.155P PS=1.72U PD=1.28U
* device instance $582 r0 *1 154.89,3.72 pfet
X$582 \$38__t0 \$235__t0 VDD__t402 VDD__t19 pfet_03v3 L=0.28U W=0.22U AS=0.155P
+ AD=0.1664P PS=1.28U PD=1.72U
* device instance $583 r0 *1 158.17,3.72 pfet
X$583 VDD__t289 \$39__t1 \$238__t1 VDD__t160 pfet_03v3 L=0.28U W=0.22U
+ AS=0.1664P AD=0.155P PS=1.72U PD=1.28U
* device instance $584 r0 *1 159.35,3.72 pfet
X$584 \$39__t0 \$238__t0 VDD__t390 VDD__t7 pfet_03v3 L=0.28U W=0.22U AS=0.155P
+ AD=0.1664P PS=1.28U PD=1.72U
* device instance $585 r0 *1 162.63,3.72 pfet
X$585 VDD__t287 \$40__t1 \$241__t1 VDD__t158 pfet_03v3 L=0.28U W=0.22U
+ AS=0.1664P AD=0.155P PS=1.72U PD=1.28U
* device instance $586 r0 *1 163.81,3.72 pfet
X$586 \$40__t0 \$241__t0 VDD__t387 VDD__t4 pfet_03v3 L=0.28U W=0.22U AS=0.155P
+ AD=0.1664P PS=1.28U PD=1.72U
* device instance $587 r0 *1 167.09,3.72 pfet
X$587 VDD__t285 \$41__t1 \$244__t1 VDD__t156 pfet_03v3 L=0.28U W=0.22U
+ AS=0.1664P AD=0.155P PS=1.72U PD=1.28U
* device instance $588 r0 *1 168.27,3.72 pfet
X$588 \$41__t0 \$244__t0 VDD__t411 VDD__t28 pfet_03v3 L=0.28U W=0.22U AS=0.155P
+ AD=0.1664P PS=1.28U PD=1.72U
* device instance $589 r0 *1 171.55,3.72 pfet
X$589 VDD__t283 \$42__t1 \$247__t1 VDD__t154 pfet_03v3 L=0.28U W=0.22U
+ AS=0.1664P AD=0.155P PS=1.72U PD=1.28U
* device instance $590 r0 *1 172.73,3.72 pfet
X$590 \$42__t0 \$247__t0 VDD__t417 VDD__t34 pfet_03v3 L=0.28U W=0.22U AS=0.155P
+ AD=0.1664P PS=1.28U PD=1.72U
* device instance $591 r0 *1 176.01,3.72 pfet
X$591 VDD__t281 \$43__t1 \$250__t1 VDD__t152 pfet_03v3 L=0.28U W=0.22U
+ AS=0.1664P AD=0.155P PS=1.72U PD=1.28U
* device instance $592 r0 *1 177.19,3.72 pfet
X$592 \$43__t0 \$250__t0 VDD__t414 VDD__t31 pfet_03v3 L=0.28U W=0.22U AS=0.155P
+ AD=0.1664P PS=1.28U PD=1.72U
* device instance $593 r0 *1 180.47,3.72 pfet
X$593 VDD__t280 \$44__t1 \$253__t1 VDD__t151 pfet_03v3 L=0.28U W=0.22U
+ AS=0.1664P AD=0.155P PS=1.72U PD=1.28U
* device instance $594 r0 *1 181.65,3.72 pfet
X$594 \$44__t0 \$253__t0 VDD__t480 VDD__t97 pfet_03v3 L=0.28U W=0.22U AS=0.155P
+ AD=0.1664P PS=1.28U PD=1.72U
* device instance $595 r0 *1 184.93,3.72 pfet
X$595 VDD__t277 \$45__t1 \$256__t1 VDD__t148 pfet_03v3 L=0.28U W=0.22U
+ AS=0.1664P AD=0.155P PS=1.72U PD=1.28U
* device instance $596 r0 *1 186.11,3.72 pfet
X$596 \$45__t0 \$256__t0 VDD__t409 VDD__t26 pfet_03v3 L=0.28U W=0.22U AS=0.155P
+ AD=0.1664P PS=1.28U PD=1.72U
* device instance $597 r0 *1 189.39,3.72 pfet
X$597 VDD__t275 \$46__t1 \$259__t1 VDD__t146 pfet_03v3 L=0.28U W=0.22U
+ AS=0.1664P AD=0.155P PS=1.72U PD=1.28U
* device instance $598 r0 *1 190.57,3.72 pfet
X$598 \$46__t0 \$259__t0 VDD__t406 VDD__t23 pfet_03v3 L=0.28U W=0.22U AS=0.155P
+ AD=0.1664P PS=1.28U PD=1.72U
* device instance $599 r0 *1 193.85,3.72 pfet
X$599 VDD__t273 \$47__t1 \$262__t1 VDD__t144 pfet_03v3 L=0.28U W=0.22U
+ AS=0.1664P AD=0.155P PS=1.72U PD=1.28U
* device instance $600 r0 *1 195.03,3.72 pfet
X$600 \$47__t0 \$262__t0 VDD__t403 VDD__t20 pfet_03v3 L=0.28U W=0.22U AS=0.155P
+ AD=0.1664P PS=1.28U PD=1.72U
* device instance $601 r0 *1 198.31,3.72 pfet
X$601 VDD__t272 \$48__t1 \$265__t1 VDD__t143 pfet_03v3 L=0.28U W=0.22U
+ AS=0.1664P AD=0.155P PS=1.72U PD=1.28U
* device instance $602 r0 *1 199.49,3.72 pfet
X$602 \$48__t0 \$265__t0 VDD__t489 VDD__t106 pfet_03v3 L=0.28U W=0.22U
+ AS=0.155P AD=0.1664P PS=1.28U PD=1.72U
* device instance $603 r0 *1 202.77,3.72 pfet
X$603 VDD__t274 \$49__t1 \$268__t1 VDD__t145 pfet_03v3 L=0.28U W=0.22U
+ AS=0.1664P AD=0.155P PS=1.72U PD=1.28U
* device instance $604 r0 *1 203.95,3.72 pfet
X$604 \$49__t0 \$268__t0 VDD__t444 VDD__t61 pfet_03v3 L=0.28U W=0.22U AS=0.155P
+ AD=0.1664P PS=1.28U PD=1.72U
* device instance $605 r0 *1 207.23,3.72 pfet
X$605 VDD__t270 \$50__t1 \$271__t1 VDD__t141 pfet_03v3 L=0.28U W=0.22U
+ AS=0.1664P AD=0.155P PS=1.72U PD=1.28U
* device instance $606 r0 *1 208.41,3.72 pfet
X$606 \$50__t0 \$271__t0 VDD__t488 VDD__t105 pfet_03v3 L=0.28U W=0.22U
+ AS=0.155P AD=0.1664P PS=1.28U PD=1.72U
* device instance $607 r0 *1 211.69,3.72 pfet
X$607 VDD__t269 \$51__t1 \$274__t1 VDD__t140 pfet_03v3 L=0.28U W=0.22U
+ AS=0.1664P AD=0.155P PS=1.72U PD=1.28U
* device instance $608 r0 *1 212.87,3.72 pfet
X$608 \$51__t0 \$274__t0 VDD__t494 VDD__t111 pfet_03v3 L=0.28U W=0.22U
+ AS=0.155P AD=0.1664P PS=1.28U PD=1.72U
* device instance $609 r0 *1 216.15,3.72 pfet
X$609 VDD__t286 \$52__t1 \$277__t1 VDD__t157 pfet_03v3 L=0.28U W=0.22U
+ AS=0.1664P AD=0.155P PS=1.72U PD=1.28U
* device instance $610 r0 *1 217.33,3.72 pfet
X$610 \$52__t0 \$277__t0 VDD__t440 VDD__t57 pfet_03v3 L=0.28U W=0.22U AS=0.155P
+ AD=0.1664P PS=1.28U PD=1.72U
* device instance $611 r0 *1 220.61,3.72 pfet
X$611 VDD__t296 \$53__t1 \$280__t1 VDD__t167 pfet_03v3 L=0.28U W=0.22U
+ AS=0.1664P AD=0.155P PS=1.72U PD=1.28U
* device instance $612 r0 *1 221.79,3.72 pfet
X$612 \$53__t0 \$280__t0 VDD__t442 VDD__t59 pfet_03v3 L=0.28U W=0.22U AS=0.155P
+ AD=0.1664P PS=1.28U PD=1.72U
* device instance $613 r0 *1 225.07,3.72 pfet
X$613 VDD__t298 \$54__t1 \$283__t1 VDD__t169 pfet_03v3 L=0.28U W=0.22U
+ AS=0.1664P AD=0.155P PS=1.72U PD=1.28U
* device instance $614 r0 *1 226.25,3.72 pfet
X$614 \$54__t0 \$283__t0 VDD__t429 VDD__t46 pfet_03v3 L=0.28U W=0.22U AS=0.155P
+ AD=0.1664P PS=1.28U PD=1.72U
* device instance $615 r0 *1 229.53,3.72 pfet
X$615 VDD__t356 \$55__t1 \$286__t1 VDD__t227 pfet_03v3 L=0.28U W=0.22U
+ AS=0.1664P AD=0.155P PS=1.72U PD=1.28U
* device instance $616 r0 *1 230.71,3.72 pfet
X$616 \$55__t0 \$286__t0 VDD__t427 VDD__t44 pfet_03v3 L=0.28U W=0.22U AS=0.155P
+ AD=0.1664P PS=1.28U PD=1.72U
* device instance $617 r0 *1 233.99,3.72 pfet
X$617 VDD__t355 \$56__t1 \$289__t1 VDD__t226 pfet_03v3 L=0.28U W=0.22U
+ AS=0.1664P AD=0.155P PS=1.72U PD=1.28U
* device instance $618 r0 *1 235.17,3.72 pfet
X$618 \$56__t0 \$289__t0 VDD__t426 VDD__t43 pfet_03v3 L=0.28U W=0.22U AS=0.155P
+ AD=0.1664P PS=1.28U PD=1.72U
* device instance $619 r0 *1 238.45,3.72 pfet
X$619 VDD__t354 \$57__t1 \$292__t1 VDD__t225 pfet_03v3 L=0.28U W=0.22U
+ AS=0.1664P AD=0.155P PS=1.72U PD=1.28U
* device instance $620 r0 *1 239.63,3.72 pfet
X$620 \$57__t0 \$292__t0 VDD__t424 VDD__t41 pfet_03v3 L=0.28U W=0.22U AS=0.155P
+ AD=0.1664P PS=1.28U PD=1.72U
* device instance $621 r0 *1 242.91,3.72 pfet
X$621 VDD__t353 \$58__t1 \$295__t1 VDD__t224 pfet_03v3 L=0.28U W=0.22U
+ AS=0.1664P AD=0.155P PS=1.72U PD=1.28U
* device instance $622 r0 *1 244.09,3.72 pfet
X$622 \$58__t0 \$295__t0 VDD__t412 VDD__t29 pfet_03v3 L=0.28U W=0.22U AS=0.155P
+ AD=0.1664P PS=1.28U PD=1.72U
* device instance $623 r0 *1 247.37,3.72 pfet
X$623 VDD__t311 \$59__t1 \$298__t1 VDD__t182 pfet_03v3 L=0.28U W=0.22U
+ AS=0.1664P AD=0.155P PS=1.72U PD=1.28U
* device instance $624 r0 *1 248.55,3.72 pfet
X$624 \$59__t0 \$298__t0 VDD__t421 VDD__t38 pfet_03v3 L=0.28U W=0.22U AS=0.155P
+ AD=0.1664P PS=1.28U PD=1.72U
* device instance $625 r0 *1 251.83,3.72 pfet
X$625 VDD__t320 \$60__t1 \$301__t1 VDD__t191 pfet_03v3 L=0.28U W=0.22U
+ AS=0.1664P AD=0.155P PS=1.72U PD=1.28U
* device instance $626 r0 *1 253.01,3.72 pfet
X$626 \$60__t0 \$301__t0 VDD__t410 VDD__t27 pfet_03v3 L=0.28U W=0.22U AS=0.155P
+ AD=0.1664P PS=1.28U PD=1.72U
* device instance $627 r0 *1 256.29,3.72 pfet
X$627 VDD__t319 \$61__t1 \$304__t1 VDD__t190 pfet_03v3 L=0.28U W=0.22U
+ AS=0.1664P AD=0.155P PS=1.72U PD=1.28U
* device instance $628 r0 *1 257.47,3.72 pfet
X$628 \$61__t0 \$304__t0 VDD__t408 VDD__t25 pfet_03v3 L=0.28U W=0.22U AS=0.155P
+ AD=0.1664P PS=1.28U PD=1.72U
* device instance $629 r0 *1 260.75,3.72 pfet
X$629 VDD__t318 \$62__t1 \$307__t1 VDD__t189 pfet_03v3 L=0.28U W=0.22U
+ AS=0.1664P AD=0.155P PS=1.72U PD=1.28U
* device instance $630 r0 *1 261.93,3.72 pfet
X$630 \$62__t0 \$307__t0 VDD__t474 VDD__t91 pfet_03v3 L=0.28U W=0.22U AS=0.155P
+ AD=0.1664P PS=1.28U PD=1.72U
* device instance $631 r0 *1 265.21,3.72 pfet
X$631 VDD__t326 \$63__t1 \$310__t1 VDD__t197 pfet_03v3 L=0.28U W=0.22U
+ AS=0.1664P AD=0.155P PS=1.72U PD=1.28U
* device instance $632 r0 *1 266.39,3.72 pfet
X$632 \$63__t0 \$310__t0 VDD__t466 VDD__t83 pfet_03v3 L=0.28U W=0.22U AS=0.155P
+ AD=0.1664P PS=1.28U PD=1.72U
* device instance $633 r0 *1 269.67,3.72 pfet
X$633 VDD__t325 \$64__t1 \$313__t1 VDD__t196 pfet_03v3 L=0.28U W=0.22U
+ AS=0.1664P AD=0.155P PS=1.72U PD=1.28U
* device instance $634 r0 *1 270.85,3.72 pfet
X$634 \$64__t0 \$313__t0 VDD__t460 VDD__t77 pfet_03v3 L=0.28U W=0.22U AS=0.155P
+ AD=0.1664P PS=1.28U PD=1.72U
* device instance $635 r0 *1 274.13,3.72 pfet
X$635 VDD__t324 \$65__t1 \$316__t1 VDD__t195 pfet_03v3 L=0.28U W=0.22U
+ AS=0.1664P AD=0.155P PS=1.72U PD=1.28U
* device instance $636 r0 *1 275.31,3.72 pfet
X$636 \$65__t0 \$316__t0 VDD__t508 VDD__t125 pfet_03v3 L=0.28U W=0.22U
+ AS=0.155P AD=0.1664P PS=1.28U PD=1.72U
* device instance $637 r0 *1 278.59,3.72 pfet
X$637 VDD__t323 \$66__t1 \$319__t1 VDD__t194 pfet_03v3 L=0.28U W=0.22U
+ AS=0.1664P AD=0.155P PS=1.72U PD=1.28U
* device instance $638 r0 *1 279.77,3.72 pfet
X$638 \$66__t0 \$319__t0 VDD__t502 VDD__t119 pfet_03v3 L=0.28U W=0.22U
+ AS=0.155P AD=0.1664P PS=1.28U PD=1.72U
* device instance $639 r0 *1 283.05,3.72 pfet
X$639 VDD__t322 \$67__t1 \$322__t1 VDD__t193 pfet_03v3 L=0.28U W=0.22U
+ AS=0.1664P AD=0.155P PS=1.72U PD=1.28U
* device instance $640 r0 *1 284.23,3.72 pfet
X$640 \$67__t0 \$322__t0 VDD__t498 VDD__t115 pfet_03v3 L=0.28U W=0.22U
+ AS=0.155P AD=0.1664P PS=1.28U PD=1.72U
* device instance $641 r0 *1 287.51,3.72 pfet
X$641 VDD__t276 \$68__t1 \$325__t1 VDD__t147 pfet_03v3 L=0.28U W=0.22U
+ AS=0.1664P AD=0.155P PS=1.72U PD=1.28U
* device instance $642 r0 *1 288.69,3.72 pfet
X$642 \$68__t0 \$325__t0 VDD__t497 VDD__t114 pfet_03v3 L=0.28U W=0.22U
+ AS=0.155P AD=0.1664P PS=1.28U PD=1.72U
* device instance $643 r0 *1 291.97,3.72 pfet
X$643 VDD__t279 \$69__t1 \$328__t1 VDD__t150 pfet_03v3 L=0.28U W=0.22U
+ AS=0.1664P AD=0.155P PS=1.72U PD=1.28U
* device instance $644 r0 *1 293.15,3.72 pfet
X$644 \$69__t0 \$328__t0 VDD__t500 VDD__t117 pfet_03v3 L=0.28U W=0.22U
+ AS=0.155P AD=0.1664P PS=1.28U PD=1.72U
* device instance $645 r0 *1 296.43,3.72 pfet
X$645 VDD__t282 \$70__t1 \$331__t1 VDD__t153 pfet_03v3 L=0.28U W=0.22U
+ AS=0.1664P AD=0.155P PS=1.72U PD=1.28U
* device instance $646 r0 *1 297.61,3.72 pfet
X$646 \$70__t0 \$331__t0 VDD__t505 VDD__t122 pfet_03v3 L=0.28U W=0.22U
+ AS=0.155P AD=0.1664P PS=1.28U PD=1.72U
* device instance $647 r0 *1 300.89,3.72 pfet
X$647 VDD__t284 \$71__t1 \$334__t1 VDD__t155 pfet_03v3 L=0.28U W=0.22U
+ AS=0.1664P AD=0.155P PS=1.72U PD=1.28U
* device instance $648 r0 *1 302.07,3.72 pfet
X$648 \$71__t0 \$334__t0 VDD__t510 VDD__t127 pfet_03v3 L=0.28U W=0.22U
+ AS=0.155P AD=0.1664P PS=1.28U PD=1.72U
* device instance $649 r0 *1 305.35,3.72 pfet
X$649 VDD__t302 \$72__t1 \$337__t1 VDD__t173 pfet_03v3 L=0.28U W=0.22U
+ AS=0.1664P AD=0.155P PS=1.72U PD=1.28U
* device instance $650 r0 *1 306.53,3.72 pfet
X$650 \$72__t0 \$337__t0 VDD__t463 VDD__t80 pfet_03v3 L=0.28U W=0.22U AS=0.155P
+ AD=0.1664P PS=1.28U PD=1.72U
* device instance $651 r0 *1 309.81,3.72 pfet
X$651 VDD__t288 \$73__t1 \$340__t1 VDD__t159 pfet_03v3 L=0.28U W=0.22U
+ AS=0.1664P AD=0.155P PS=1.72U PD=1.28U
* device instance $652 r0 *1 310.99,3.72 pfet
X$652 \$73__t0 \$340__t0 VDD__t468 VDD__t85 pfet_03v3 L=0.28U W=0.22U AS=0.155P
+ AD=0.1664P PS=1.28U PD=1.72U
* device instance $653 r0 *1 314.27,3.72 pfet
X$653 VDD__t291 \$74__t1 \$343__t1 VDD__t162 pfet_03v3 L=0.28U W=0.22U
+ AS=0.1664P AD=0.155P PS=1.72U PD=1.28U
* device instance $654 r0 *1 315.45,3.72 pfet
X$654 \$74__t0 \$343__t0 VDD__t473 VDD__t90 pfet_03v3 L=0.28U W=0.22U AS=0.155P
+ AD=0.1664P PS=1.28U PD=1.72U
* device instance $655 r0 *1 318.73,3.72 pfet
X$655 VDD__t293 \$75__t1 \$346__t1 VDD__t164 pfet_03v3 L=0.28U W=0.22U
+ AS=0.1664P AD=0.155P PS=1.72U PD=1.28U
* device instance $656 r0 *1 319.91,3.72 pfet
X$656 \$75__t0 \$346__t0 VDD__t479 VDD__t96 pfet_03v3 L=0.28U W=0.22U AS=0.155P
+ AD=0.1664P PS=1.28U PD=1.72U
* device instance $657 r0 *1 323.19,3.72 pfet
X$657 VDD__t295 \$76__t1 \$349__t1 VDD__t166 pfet_03v3 L=0.28U W=0.22U
+ AS=0.1664P AD=0.155P PS=1.72U PD=1.28U
* device instance $658 r0 *1 324.37,3.72 pfet
X$658 \$76__t0 \$349__t0 VDD__t471 VDD__t88 pfet_03v3 L=0.28U W=0.22U AS=0.155P
+ AD=0.1664P PS=1.28U PD=1.72U
* device instance $659 r0 *1 327.65,3.72 pfet
X$659 VDD__t297 \$77__t1 \$352__t1 VDD__t168 pfet_03v3 L=0.28U W=0.22U
+ AS=0.1664P AD=0.155P PS=1.72U PD=1.28U
* device instance $660 r0 *1 328.83,3.72 pfet
X$660 \$77__t0 \$352__t0 VDD__t499 VDD__t116 pfet_03v3 L=0.28U W=0.22U
+ AS=0.155P AD=0.1664P PS=1.28U PD=1.72U
* device instance $661 r0 *1 332.11,3.72 pfet
X$661 VDD__t300 \$78__t1 \$355__t1 VDD__t171 pfet_03v3 L=0.28U W=0.22U
+ AS=0.1664P AD=0.155P PS=1.72U PD=1.28U
* device instance $662 r0 *1 333.29,3.72 pfet
X$662 \$78__t0 \$355__t0 VDD__t491 VDD__t108 pfet_03v3 L=0.28U W=0.22U
+ AS=0.155P AD=0.1664P PS=1.28U PD=1.72U
* device instance $663 r0 *1 336.57,3.72 pfet
X$663 VDD__t271 \$79__t1 \$358__t1 VDD__t142 pfet_03v3 L=0.28U W=0.22U
+ AS=0.1664P AD=0.155P PS=1.72U PD=1.28U
* device instance $664 r0 *1 337.75,3.72 pfet
X$664 \$79__t0 \$358__t0 VDD__t470 VDD__t87 pfet_03v3 L=0.28U W=0.22U AS=0.155P
+ AD=0.1664P PS=1.28U PD=1.72U
* device instance $665 r0 *1 341.03,3.72 pfet
X$665 VDD__t259 \$80__t1 \$361__t1 VDD__t130 pfet_03v3 L=0.28U W=0.22U
+ AS=0.1664P AD=0.155P PS=1.72U PD=1.28U
* device instance $666 r0 *1 342.21,3.72 pfet
X$666 \$80__t0 \$361__t0 VDD__t476 VDD__t93 pfet_03v3 L=0.28U W=0.22U AS=0.155P
+ AD=0.1664P PS=1.28U PD=1.72U
* device instance $667 r0 *1 345.49,3.72 pfet
X$667 VDD__t262 \$81__t1 \$364__t1 VDD__t133 pfet_03v3 L=0.28U W=0.22U
+ AS=0.1664P AD=0.155P PS=1.72U PD=1.28U
* device instance $668 r0 *1 346.67,3.72 pfet
X$668 \$81__t0 \$364__t0 VDD__t465 VDD__t82 pfet_03v3 L=0.28U W=0.22U AS=0.155P
+ AD=0.1664P PS=1.28U PD=1.72U
* device instance $669 r0 *1 349.95,3.72 pfet
X$669 VDD__t264 \$82__t1 \$367__t1 VDD__t135 pfet_03v3 L=0.28U W=0.22U
+ AS=0.1664P AD=0.155P PS=1.72U PD=1.28U
* device instance $670 r0 *1 351.13,3.72 pfet
X$670 \$82__t0 \$367__t0 VDD__t503 VDD__t120 pfet_03v3 L=0.28U W=0.22U
+ AS=0.155P AD=0.1664P PS=1.28U PD=1.72U
* device instance $671 r0 *1 354.41,3.72 pfet
X$671 VDD__t266 \$83__t1 \$370__t1 VDD__t137 pfet_03v3 L=0.28U W=0.22U
+ AS=0.1664P AD=0.155P PS=1.72U PD=1.28U
* device instance $672 r0 *1 355.59,3.72 pfet
X$672 \$83__t0 \$370__t0 VDD__t496 VDD__t113 pfet_03v3 L=0.28U W=0.22U
+ AS=0.155P AD=0.1664P PS=1.28U PD=1.72U
* device instance $673 r0 *1 358.87,3.72 pfet
X$673 VDD__t357 \$84__t1 \$373__t1 VDD__t228 pfet_03v3 L=0.28U W=0.22U
+ AS=0.1664P AD=0.155P PS=1.72U PD=1.28U
* device instance $674 r0 *1 360.05,3.72 pfet
X$674 \$84__t0 \$373__t0 VDD__t439 VDD__t56 pfet_03v3 L=0.28U W=0.22U AS=0.155P
+ AD=0.1664P PS=1.28U PD=1.72U
* device instance $675 r0 *1 363.33,3.72 pfet
X$675 VDD__t358 \$85__t1 \$376__t1 VDD__t229 pfet_03v3 L=0.28U W=0.22U
+ AS=0.1664P AD=0.155P PS=1.72U PD=1.28U
* device instance $676 r0 *1 364.51,3.72 pfet
X$676 \$85__t0 \$376__t0 VDD__t432 VDD__t49 pfet_03v3 L=0.28U W=0.22U AS=0.155P
+ AD=0.1664P PS=1.28U PD=1.72U
* device instance $677 r0 *1 367.79,3.72 pfet
X$677 VDD__t359 \$86__t1 \$379__t1 VDD__t230 pfet_03v3 L=0.28U W=0.22U
+ AS=0.1664P AD=0.155P PS=1.72U PD=1.28U
* device instance $678 r0 *1 368.97,3.72 pfet
X$678 \$86__t0 \$379__t0 VDD__t433 VDD__t50 pfet_03v3 L=0.28U W=0.22U AS=0.155P
+ AD=0.1664P PS=1.28U PD=1.72U
* device instance $679 r0 *1 372.25,3.72 pfet
X$679 VDD__t360 \$87__t1 \$382__t1 VDD__t231 pfet_03v3 L=0.28U W=0.22U
+ AS=0.1664P AD=0.155P PS=1.72U PD=1.28U
* device instance $680 r0 *1 373.43,3.72 pfet
X$680 \$87__t0 \$382__t0 VDD__t435 VDD__t52 pfet_03v3 L=0.28U W=0.22U AS=0.155P
+ AD=0.1664P PS=1.28U PD=1.72U
* device instance $681 r0 *1 376.71,3.72 pfet
X$681 VDD__t361 \$88__t1 \$385__t1 VDD__t232 pfet_03v3 L=0.28U W=0.22U
+ AS=0.1664P AD=0.155P PS=1.72U PD=1.28U
* device instance $682 r0 *1 377.89,3.72 pfet
X$682 \$88__t0 \$385__t0 VDD__t436 VDD__t53 pfet_03v3 L=0.28U W=0.22U AS=0.155P
+ AD=0.1664P PS=1.28U PD=1.72U
* device instance $683 r0 *1 381.17,3.72 pfet
X$683 VDD__t364 \$89__t1 \$388__t1 VDD__t235 pfet_03v3 L=0.28U W=0.22U
+ AS=0.1664P AD=0.155P PS=1.72U PD=1.28U
* device instance $684 r0 *1 382.35,3.72 pfet
X$684 \$89__t0 \$388__t0 VDD__t438 VDD__t55 pfet_03v3 L=0.28U W=0.22U AS=0.155P
+ AD=0.1664P PS=1.28U PD=1.72U
* device instance $685 r0 *1 385.63,3.72 pfet
X$685 VDD__t278 \$90__t1 \$391__t1 VDD__t149 pfet_03v3 L=0.28U W=0.22U
+ AS=0.1664P AD=0.155P PS=1.72U PD=1.28U
* device instance $686 r0 *1 386.81,3.72 pfet
X$686 \$90__t0 \$391__t0 VDD__t437 VDD__t54 pfet_03v3 L=0.28U W=0.22U AS=0.155P
+ AD=0.1664P PS=1.28U PD=1.72U
* device instance $687 r0 *1 390.09,3.72 pfet
X$687 VDD__t268 \$91__t1 \$394__t1 VDD__t139 pfet_03v3 L=0.28U W=0.22U
+ AS=0.1664P AD=0.155P PS=1.72U PD=1.28U
* device instance $688 r0 *1 391.27,3.72 pfet
X$688 \$91__t0 \$394__t0 VDD__t434 VDD__t51 pfet_03v3 L=0.28U W=0.22U AS=0.155P
+ AD=0.1664P PS=1.28U PD=1.72U
* device instance $689 r0 *1 394.55,3.72 pfet
X$689 VDD__t267 \$92__t1 \$397__t1 VDD__t138 pfet_03v3 L=0.28U W=0.22U
+ AS=0.1664P AD=0.155P PS=1.72U PD=1.28U
* device instance $690 r0 *1 395.73,3.72 pfet
X$690 \$92__t0 \$397__t0 VDD__t431 VDD__t48 pfet_03v3 L=0.28U W=0.22U AS=0.155P
+ AD=0.1664P PS=1.28U PD=1.72U
* device instance $691 r0 *1 399.01,3.72 pfet
X$691 VDD__t265 \$93__t1 \$400__t1 VDD__t136 pfet_03v3 L=0.28U W=0.22U
+ AS=0.1664P AD=0.155P PS=1.72U PD=1.28U
* device instance $692 r0 *1 400.19,3.72 pfet
X$692 \$93__t0 \$400__t0 VDD__t428 VDD__t45 pfet_03v3 L=0.28U W=0.22U AS=0.155P
+ AD=0.1664P PS=1.28U PD=1.72U
* device instance $693 r0 *1 403.47,3.72 pfet
X$693 VDD__t263 \$94__t1 \$403__t1 VDD__t134 pfet_03v3 L=0.28U W=0.22U
+ AS=0.1664P AD=0.155P PS=1.72U PD=1.28U
* device instance $694 r0 *1 404.65,3.72 pfet
X$694 \$94__t0 \$403__t0 VDD__t425 VDD__t42 pfet_03v3 L=0.28U W=0.22U AS=0.155P
+ AD=0.1664P PS=1.28U PD=1.72U
* device instance $695 r0 *1 407.93,3.72 pfet
X$695 VDD__t261 \$95__t1 \$406__t1 VDD__t132 pfet_03v3 L=0.28U W=0.22U
+ AS=0.1664P AD=0.155P PS=1.72U PD=1.28U
* device instance $696 r0 *1 409.11,3.72 pfet
X$696 \$95__t0 \$406__t0 VDD__t422 VDD__t39 pfet_03v3 L=0.28U W=0.22U AS=0.155P
+ AD=0.1664P PS=1.28U PD=1.72U
* device instance $697 r0 *1 412.39,3.72 pfet
X$697 VDD__t260 \$96__t1 \$409__t1 VDD__t131 pfet_03v3 L=0.28U W=0.22U
+ AS=0.1664P AD=0.155P PS=1.72U PD=1.28U
* device instance $698 r0 *1 413.57,3.72 pfet
X$698 \$96__t0 \$409__t0 VDD__t456 VDD__t73 pfet_03v3 L=0.28U W=0.22U AS=0.155P
+ AD=0.1664P PS=1.28U PD=1.72U
* device instance $699 r0 *1 416.85,3.72 pfet
X$699 VDD__t258 \$97__t1 \$412__t1 VDD__t129 pfet_03v3 L=0.28U W=0.22U
+ AS=0.1664P AD=0.155P PS=1.72U PD=1.28U
* device instance $700 r0 *1 418.03,3.72 pfet
X$700 \$97__t0 \$412__t0 VDD__t453 VDD__t70 pfet_03v3 L=0.28U W=0.22U AS=0.155P
+ AD=0.1664P PS=1.28U PD=1.72U
* device instance $701 r0 *1 421.31,3.72 pfet
X$701 VDD__t301 \$98__t1 \$415__t1 VDD__t172 pfet_03v3 L=0.28U W=0.22U
+ AS=0.1664P AD=0.155P PS=1.72U PD=1.28U
* device instance $702 r0 *1 422.49,3.72 pfet
X$702 \$98__t0 \$415__t0 VDD__t450 VDD__t67 pfet_03v3 L=0.28U W=0.22U AS=0.155P
+ AD=0.1664P PS=1.28U PD=1.72U
* device instance $703 r0 *1 425.77,3.72 pfet
X$703 VDD__t299 \$99__t1 \$418__t1 VDD__t170 pfet_03v3 L=0.28U W=0.22U
+ AS=0.1664P AD=0.155P PS=1.72U PD=1.28U
* device instance $704 r0 *1 426.95,3.72 pfet
X$704 \$99__t0 \$418__t0 VDD__t447 VDD__t64 pfet_03v3 L=0.28U W=0.22U AS=0.155P
+ AD=0.1664P PS=1.28U PD=1.72U
* device instance $705 r0 *1 430.23,3.72 pfet
X$705 VDD__t383 \$100__t1 \$421__t1 VDD__t254 pfet_03v3 L=0.28U W=0.22U
+ AS=0.1664P AD=0.155P PS=1.72U PD=1.28U
* device instance $706 r0 *1 431.41,3.72 pfet
X$706 \$100__t0 \$421__t0 VDD__t413 VDD__t30 pfet_03v3 L=0.28U W=0.22U
+ AS=0.155P AD=0.1664P PS=1.28U PD=1.72U
* device instance $707 r0 *1 434.69,3.72 pfet
X$707 VDD__t365 \$101__t1 \$424__t1 VDD__t236 pfet_03v3 L=0.28U W=0.22U
+ AS=0.1664P AD=0.155P PS=1.72U PD=1.28U
* device instance $708 r0 *1 435.87,3.72 pfet
X$708 \$101__t0 \$424__t0 VDD__t415 VDD__t32 pfet_03v3 L=0.28U W=0.22U
+ AS=0.155P AD=0.1664P PS=1.28U PD=1.72U
* device instance $709 r0 *1 439.15,3.72 pfet
X$709 VDD__t366 \$102__t1 \$427__t1 VDD__t237 pfet_03v3 L=0.28U W=0.22U
+ AS=0.1664P AD=0.155P PS=1.72U PD=1.28U
* device instance $710 r0 *1 440.33,3.72 pfet
X$710 \$102__t0 \$427__t0 VDD__t416 VDD__t33 pfet_03v3 L=0.28U W=0.22U
+ AS=0.155P AD=0.1664P PS=1.28U PD=1.72U
* device instance $711 r0 *1 443.61,3.72 pfet
X$711 VDD__t367 \$103__t1 \$430__t1 VDD__t238 pfet_03v3 L=0.28U W=0.22U
+ AS=0.1664P AD=0.155P PS=1.72U PD=1.28U
* device instance $712 r0 *1 444.79,3.72 pfet
X$712 \$103__t0 \$430__t0 VDD__t418 VDD__t35 pfet_03v3 L=0.28U W=0.22U
+ AS=0.155P AD=0.1664P PS=1.28U PD=1.72U
* device instance $713 r0 *1 448.07,3.72 pfet
X$713 VDD__t352 \$104__t1 \$433__t1 VDD__t223 pfet_03v3 L=0.28U W=0.22U
+ AS=0.1664P AD=0.155P PS=1.72U PD=1.28U
* device instance $714 r0 *1 449.25,3.72 pfet
X$714 \$104__t0 \$433__t0 VDD__t443 VDD__t60 pfet_03v3 L=0.28U W=0.22U
+ AS=0.155P AD=0.1664P PS=1.28U PD=1.72U
* device instance $715 r0 *1 452.53,3.72 pfet
X$715 VDD__t362 \$105__t1 \$436__t1 VDD__t233 pfet_03v3 L=0.28U W=0.22U
+ AS=0.1664P AD=0.155P PS=1.72U PD=1.28U
* device instance $716 r0 *1 453.71,3.72 pfet
X$716 \$105__t0 \$436__t0 VDD__t445 VDD__t62 pfet_03v3 L=0.28U W=0.22U
+ AS=0.155P AD=0.1664P PS=1.28U PD=1.72U
* device instance $717 r0 *1 456.99,3.72 pfet
X$717 VDD__t343 \$106__t1 \$439__t1 VDD__t214 pfet_03v3 L=0.28U W=0.22U
+ AS=0.1664P AD=0.155P PS=1.72U PD=1.28U
* device instance $718 r0 *1 458.17,3.72 pfet
X$718 \$106__t0 \$439__t0 VDD__t446 VDD__t63 pfet_03v3 L=0.28U W=0.22U
+ AS=0.155P AD=0.1664P PS=1.28U PD=1.72U
* device instance $719 r0 *1 461.45,3.72 pfet
X$719 VDD__t344 \$107__t1 \$442__t1 VDD__t215 pfet_03v3 L=0.28U W=0.22U
+ AS=0.1664P AD=0.155P PS=1.72U PD=1.28U
* device instance $720 r0 *1 462.63,3.72 pfet
X$720 \$107__t0 \$442__t0 VDD__t458 VDD__t75 pfet_03v3 L=0.28U W=0.22U
+ AS=0.155P AD=0.1664P PS=1.28U PD=1.72U
* device instance $721 r0 *1 465.91,3.72 pfet
X$721 VDD__t345 \$108__t1 \$445__t1 VDD__t216 pfet_03v3 L=0.28U W=0.22U
+ AS=0.1664P AD=0.155P PS=1.72U PD=1.28U
* device instance $722 r0 *1 467.09,3.72 pfet
X$722 \$108__t0 \$445__t0 VDD__t449 VDD__t66 pfet_03v3 L=0.28U W=0.22U
+ AS=0.155P AD=0.1664P PS=1.28U PD=1.72U
* device instance $723 r0 *1 470.37,3.72 pfet
X$723 VDD__t346 \$109__t1 \$448__t1 VDD__t217 pfet_03v3 L=0.28U W=0.22U
+ AS=0.1664P AD=0.155P PS=1.72U PD=1.28U
* device instance $724 r0 *1 471.55,3.72 pfet
X$724 \$109__t0 \$448__t0 VDD__t451 VDD__t68 pfet_03v3 L=0.28U W=0.22U
+ AS=0.155P AD=0.1664P PS=1.28U PD=1.72U
* device instance $725 r0 *1 474.83,3.72 pfet
X$725 VDD__t347 \$110__t1 \$451__t1 VDD__t218 pfet_03v3 L=0.28U W=0.22U
+ AS=0.1664P AD=0.155P PS=1.72U PD=1.28U
* device instance $726 r0 *1 476.01,3.72 pfet
X$726 \$110__t0 \$451__t0 VDD__t452 VDD__t69 pfet_03v3 L=0.28U W=0.22U
+ AS=0.155P AD=0.1664P PS=1.28U PD=1.72U
* device instance $727 r0 *1 479.29,3.72 pfet
X$727 VDD__t348 \$111__t1 \$454__t1 VDD__t219 pfet_03v3 L=0.28U W=0.22U
+ AS=0.1664P AD=0.155P PS=1.72U PD=1.28U
* device instance $728 r0 *1 480.47,3.72 pfet
X$728 \$111__t0 \$454__t0 VDD__t454 VDD__t71 pfet_03v3 L=0.28U W=0.22U
+ AS=0.155P AD=0.1664P PS=1.28U PD=1.72U
* device instance $729 r0 *1 483.75,3.72 pfet
X$729 VDD__t349 \$112__t1 \$457__t1 VDD__t220 pfet_03v3 L=0.28U W=0.22U
+ AS=0.1664P AD=0.155P PS=1.72U PD=1.28U
* device instance $730 r0 *1 484.93,3.72 pfet
X$730 \$112__t0 \$457__t0 VDD__t455 VDD__t72 pfet_03v3 L=0.28U W=0.22U
+ AS=0.155P AD=0.1664P PS=1.28U PD=1.72U
* device instance $731 r0 *1 488.21,3.72 pfet
X$731 VDD__t350 \$113__t1 \$460__t1 VDD__t221 pfet_03v3 L=0.28U W=0.22U
+ AS=0.1664P AD=0.155P PS=1.72U PD=1.28U
* device instance $732 r0 *1 489.39,3.72 pfet
X$732 \$113__t0 \$460__t0 VDD__t457 VDD__t74 pfet_03v3 L=0.28U W=0.22U
+ AS=0.155P AD=0.1664P PS=1.28U PD=1.72U
* device instance $733 r0 *1 492.67,3.72 pfet
X$733 VDD__t351 \$114__t1 \$463__t1 VDD__t222 pfet_03v3 L=0.28U W=0.22U
+ AS=0.1664P AD=0.155P PS=1.72U PD=1.28U
* device instance $734 r0 *1 493.85,3.72 pfet
X$734 \$114__t0 \$463__t0 VDD__t448 VDD__t65 pfet_03v3 L=0.28U W=0.22U
+ AS=0.155P AD=0.1664P PS=1.28U PD=1.72U
* device instance $735 r0 *1 497.13,3.72 pfet
X$735 VDD__t363 \$115__t1 \$466__t1 VDD__t234 pfet_03v3 L=0.28U W=0.22U
+ AS=0.1664P AD=0.155P PS=1.72U PD=1.28U
* device instance $736 r0 *1 498.31,3.72 pfet
X$736 \$115__t0 \$466__t0 VDD__t423 VDD__t40 pfet_03v3 L=0.28U W=0.22U
+ AS=0.155P AD=0.1664P PS=1.28U PD=1.72U
* device instance $737 r0 *1 501.59,3.72 pfet
X$737 VDD__t327 \$116__t1 \$469__t1 VDD__t198 pfet_03v3 L=0.28U W=0.22U
+ AS=0.1664P AD=0.155P PS=1.72U PD=1.28U
* device instance $738 r0 *1 502.77,3.72 pfet
X$738 \$116__t0 \$469__t0 VDD__t478 VDD__t95 pfet_03v3 L=0.28U W=0.22U
+ AS=0.155P AD=0.1664P PS=1.28U PD=1.72U
* device instance $739 r0 *1 506.05,3.72 pfet
X$739 VDD__t328 \$117__t1 \$472__t1 VDD__t199 pfet_03v3 L=0.28U W=0.22U
+ AS=0.1664P AD=0.155P PS=1.72U PD=1.28U
* device instance $740 r0 *1 507.23,3.72 pfet
X$740 \$117__t0 \$472__t0 VDD__t485 VDD__t102 pfet_03v3 L=0.28U W=0.22U
+ AS=0.155P AD=0.1664P PS=1.28U PD=1.72U
* device instance $741 r0 *1 510.51,3.72 pfet
X$741 VDD__t329 \$118__t1 \$475__t1 VDD__t200 pfet_03v3 L=0.28U W=0.22U
+ AS=0.1664P AD=0.155P PS=1.72U PD=1.28U
* device instance $742 r0 *1 511.69,3.72 pfet
X$742 \$118__t0 \$475__t0 VDD__t511 VDD__t128 pfet_03v3 L=0.28U W=0.22U
+ AS=0.155P AD=0.1664P PS=1.28U PD=1.72U
* device instance $743 r0 *1 514.97,3.72 pfet
X$743 VDD__t330 \$119__t1 \$478__t1 VDD__t201 pfet_03v3 L=0.28U W=0.22U
+ AS=0.1664P AD=0.155P PS=1.72U PD=1.28U
* device instance $744 r0 *1 516.15,3.72 pfet
X$744 \$119__t0 \$478__t0 VDD__t486 VDD__t103 pfet_03v3 L=0.28U W=0.22U
+ AS=0.155P AD=0.1664P PS=1.28U PD=1.72U
* device instance $745 r0 *1 519.43,3.72 pfet
X$745 VDD__t342 \$120__t1 \$481__t1 VDD__t213 pfet_03v3 L=0.28U W=0.22U
+ AS=0.1664P AD=0.155P PS=1.72U PD=1.28U
* device instance $746 r0 *1 520.61,3.72 pfet
X$746 \$120__t0 \$481__t0 VDD__t492 VDD__t109 pfet_03v3 L=0.28U W=0.22U
+ AS=0.155P AD=0.1664P PS=1.28U PD=1.72U
* device instance $747 r0 *1 523.89,3.72 pfet
X$747 VDD__t332 \$121__t1 \$484__t1 VDD__t203 pfet_03v3 L=0.28U W=0.22U
+ AS=0.1664P AD=0.155P PS=1.72U PD=1.28U
* device instance $748 r0 *1 525.07,3.72 pfet
X$748 \$121__t0 \$484__t0 VDD__t507 VDD__t124 pfet_03v3 L=0.28U W=0.22U
+ AS=0.155P AD=0.1664P PS=1.28U PD=1.72U
* device instance $749 r0 *1 528.35,3.72 pfet
X$749 VDD__t333 \$122__t1 \$487__t1 VDD__t204 pfet_03v3 L=0.28U W=0.22U
+ AS=0.1664P AD=0.155P PS=1.72U PD=1.28U
* device instance $750 r0 *1 529.53,3.72 pfet
X$750 \$122__t0 \$487__t0 VDD__t462 VDD__t79 pfet_03v3 L=0.28U W=0.22U
+ AS=0.155P AD=0.1664P PS=1.28U PD=1.72U
* device instance $751 r0 *1 532.81,3.72 pfet
X$751 VDD__t334 \$123__t1 \$490__t1 VDD__t205 pfet_03v3 L=0.28U W=0.22U
+ AS=0.1664P AD=0.155P PS=1.72U PD=1.28U
* device instance $752 r0 *1 533.99,3.72 pfet
X$752 \$123__t0 \$490__t0 VDD__t482 VDD__t99 pfet_03v3 L=0.28U W=0.22U
+ AS=0.155P AD=0.1664P PS=1.28U PD=1.72U
* device instance $753 r0 *1 537.27,3.72 pfet
X$753 VDD__t310 \$124__t1 \$493__t1 VDD__t181 pfet_03v3 L=0.28U W=0.22U
+ AS=0.1664P AD=0.155P PS=1.72U PD=1.28U
* device instance $754 r0 *1 538.45,3.72 pfet
X$754 \$124__t0 \$493__t0 VDD__t495 VDD__t112 pfet_03v3 L=0.28U W=0.22U
+ AS=0.155P AD=0.1664P PS=1.28U PD=1.72U
* device instance $755 r0 *1 541.73,3.72 pfet
X$755 VDD__t321 \$125__t1 \$496__t1 VDD__t192 pfet_03v3 L=0.28U W=0.22U
+ AS=0.1664P AD=0.155P PS=1.72U PD=1.28U
* device instance $756 r0 *1 542.91,3.72 pfet
X$756 \$125__t0 \$496__t0 VDD__t493 VDD__t110 pfet_03v3 L=0.28U W=0.22U
+ AS=0.155P AD=0.1664P PS=1.28U PD=1.72U
* device instance $757 r0 *1 546.19,3.72 pfet
X$757 VDD__t312 \$126__t1 \$499__t1 VDD__t183 pfet_03v3 L=0.28U W=0.22U
+ AS=0.1664P AD=0.155P PS=1.72U PD=1.28U
* device instance $758 r0 *1 547.37,3.72 pfet
X$758 \$126__t0 \$499__t0 VDD__t490 VDD__t107 pfet_03v3 L=0.28U W=0.22U
+ AS=0.155P AD=0.1664P PS=1.28U PD=1.72U
* device instance $759 r0 *1 550.65,3.72 pfet
X$759 VDD__t313 \$127__t1 \$502__t1 VDD__t184 pfet_03v3 L=0.28U W=0.22U
+ AS=0.1664P AD=0.155P PS=1.72U PD=1.28U
* device instance $760 r0 *1 551.83,3.72 pfet
X$760 \$127__t0 \$502__t0 VDD__t487 VDD__t104 pfet_03v3 L=0.28U W=0.22U
+ AS=0.155P AD=0.1664P PS=1.28U PD=1.72U
* device instance $761 r0 *1 555.11,3.72 pfet
X$761 VDD__t314 \$128__t1 \$505__t1 VDD__t185 pfet_03v3 L=0.28U W=0.22U
+ AS=0.1664P AD=0.155P PS=1.72U PD=1.28U
* device instance $762 r0 *1 556.29,3.72 pfet
X$762 \$128__t0 \$505__t0 VDD__t393 VDD__t10 pfet_03v3 L=0.28U W=0.22U
+ AS=0.155P AD=0.1664P PS=1.28U PD=1.72U
* device instance $763 r0 *1 559.57,3.72 pfet
X$763 VDD__t315 \$129__t1 \$508__t1 VDD__t186 pfet_03v3 L=0.28U W=0.22U
+ AS=0.1664P AD=0.155P PS=1.72U PD=1.28U
* device instance $764 r0 *1 560.75,3.72 pfet
X$764 \$129__t0 \$508__t0 VDD__t404 VDD__t21 pfet_03v3 L=0.28U W=0.22U
+ AS=0.155P AD=0.1664P PS=1.28U PD=1.72U
* device instance $765 r0 *1 564.03,3.72 pfet
X$765 VDD__t316 \$130__t1 \$511__t1 VDD__t187 pfet_03v3 L=0.28U W=0.22U
+ AS=0.1664P AD=0.155P PS=1.72U PD=1.28U
* device instance $766 r0 *1 565.21,3.72 pfet
X$766 \$130__t0 \$511__t0 VDD__t405 VDD__t22 pfet_03v3 L=0.28U W=0.22U
+ AS=0.155P AD=0.1664P PS=1.28U PD=1.72U
* device instance $767 r0 *1 568.49,3.72 pfet
X$767 VDD__t317 \$131__t1 \$514__t1 VDD__t188 pfet_03v3 L=0.28U W=0.22U
+ AS=0.1664P AD=0.155P PS=1.72U PD=1.28U
* device instance $768 r0 *1 569.67,3.72 pfet
X$768 \$131__t0 \$514__t0 VDD__t407 VDD__t24 pfet_03v3 L=0.28U W=0.22U
+ AS=0.155P AD=0.1664P PS=1.28U PD=1.72U
* device instance _10_t0 r0 *1 0,0
R_10_t0 \$10__t0 \$10 14.0706287935
* device instance _10_t1 r0 *1 0,0
R_10_t1 \$10__t1 \$10 17.162141452
* device instance _10_t2 r0 *1 0,0
R_10_t2 \$10__t2 \$10 13.6875065396
* device instance _10_t3 r0 *1 0,0
R_10_t3 \$10__t3 \$10 9.52844849363
* device instance _10_t4 r0 *1 0,0
R_10_t4 \$10__t4 \$10 16.7641747213
* device instance _10 r0 *1 0,0
C_10 \$10 vsubs 7.92193e-16
* device instance _100_t0 r0 *1 0,0
R_100_t0 \$100__t0 \$100 14.0706287935
* device instance _100_t1 r0 *1 0,0
R_100_t1 \$100__t1 \$100 17.162141452
* device instance _100_t2 r0 *1 0,0
R_100_t2 \$100__t2 \$100 13.6875065396
* device instance _100_t3 r0 *1 0,0
R_100_t3 \$100__t3 \$100 9.52844849363
* device instance _100_t4 r0 *1 0,0
R_100_t4 \$100__t4 \$100 16.7641747213
* device instance _100 r0 *1 0,0
C_100 \$100 vsubs 7.92193e-16
* device instance _101_t0 r0 *1 0,0
R_101_t0 \$101__t0 \$101 14.0706287935
* device instance _101_t1 r0 *1 0,0
R_101_t1 \$101__t1 \$101 17.162141452
* device instance _101_t2 r0 *1 0,0
R_101_t2 \$101__t2 \$101 13.6875065396
* device instance _101_t3 r0 *1 0,0
R_101_t3 \$101__t3 \$101 9.52844849363
* device instance _101_t4 r0 *1 0,0
R_101_t4 \$101__t4 \$101 16.7641747213
* device instance _101 r0 *1 0,0
C_101 \$101 vsubs 7.92193e-16
* device instance _102_t0 r0 *1 0,0
R_102_t0 \$102__t0 \$102 14.0706287935
* device instance _102_t1 r0 *1 0,0
R_102_t1 \$102__t1 \$102 17.162141452
* device instance _102_t2 r0 *1 0,0
R_102_t2 \$102__t2 \$102 13.6875065396
* device instance _102_t3 r0 *1 0,0
R_102_t3 \$102__t3 \$102 9.52844849363
* device instance _102_t4 r0 *1 0,0
R_102_t4 \$102__t4 \$102 16.7641747213
* device instance _102 r0 *1 0,0
C_102 \$102 vsubs 7.92193e-16
* device instance _103_t0 r0 *1 0,0
R_103_t0 \$103__t0 \$103 14.0706287935
* device instance _103_t1 r0 *1 0,0
R_103_t1 \$103__t1 \$103 17.162141452
* device instance _103_t2 r0 *1 0,0
R_103_t2 \$103__t2 \$103 13.6875065396
* device instance _103_t3 r0 *1 0,0
R_103_t3 \$103__t3 \$103 9.52844849363
* device instance _103_t4 r0 *1 0,0
R_103_t4 \$103__t4 \$103 16.7641747213
* device instance _103 r0 *1 0,0
C_103 \$103 vsubs 7.92193e-16
* device instance _104_t0 r0 *1 0,0
R_104_t0 \$104__t0 \$104 14.0706287935
* device instance _104_t1 r0 *1 0,0
R_104_t1 \$104__t1 \$104 17.162141452
* device instance _104_t2 r0 *1 0,0
R_104_t2 \$104__t2 \$104 13.6875065396
* device instance _104_t3 r0 *1 0,0
R_104_t3 \$104__t3 \$104 9.52844849363
* device instance _104_t4 r0 *1 0,0
R_104_t4 \$104__t4 \$104 16.7641747213
* device instance _104 r0 *1 0,0
C_104 \$104 vsubs 7.92193e-16
* device instance _105_t0 r0 *1 0,0
R_105_t0 \$105__t0 \$105 14.0706287935
* device instance _105_t1 r0 *1 0,0
R_105_t1 \$105__t1 \$105 17.162141452
* device instance _105_t2 r0 *1 0,0
R_105_t2 \$105__t2 \$105 13.6875065396
* device instance _105_t3 r0 *1 0,0
R_105_t3 \$105__t3 \$105 9.52844849363
* device instance _105_t4 r0 *1 0,0
R_105_t4 \$105__t4 \$105 16.7641747213
* device instance _105 r0 *1 0,0
C_105 \$105 vsubs 7.92193e-16
* device instance _106_t0 r0 *1 0,0
R_106_t0 \$106__t0 \$106 14.0706287935
* device instance _106_t1 r0 *1 0,0
R_106_t1 \$106__t1 \$106 17.162141452
* device instance _106_t2 r0 *1 0,0
R_106_t2 \$106__t2 \$106 13.6875065396
* device instance _106_t3 r0 *1 0,0
R_106_t3 \$106__t3 \$106 9.52844849363
* device instance _106_t4 r0 *1 0,0
R_106_t4 \$106__t4 \$106 16.7641747213
* device instance _106 r0 *1 0,0
C_106 \$106 vsubs 7.92193e-16
* device instance _107_t0 r0 *1 0,0
R_107_t0 \$107__t0 \$107 14.0706287935
* device instance _107_t1 r0 *1 0,0
R_107_t1 \$107__t1 \$107 17.162141452
* device instance _107_t2 r0 *1 0,0
R_107_t2 \$107__t2 \$107 13.6875065396
* device instance _107_t3 r0 *1 0,0
R_107_t3 \$107__t3 \$107 9.52844849363
* device instance _107_t4 r0 *1 0,0
R_107_t4 \$107__t4 \$107 16.7641747213
* device instance _107 r0 *1 0,0
C_107 \$107 vsubs 7.92193e-16
* device instance _108_t0 r0 *1 0,0
R_108_t0 \$108__t0 \$108 14.0706287935
* device instance _108_t1 r0 *1 0,0
R_108_t1 \$108__t1 \$108 17.162141452
* device instance _108_t2 r0 *1 0,0
R_108_t2 \$108__t2 \$108 13.6875065396
* device instance _108_t3 r0 *1 0,0
R_108_t3 \$108__t3 \$108 9.52844849363
* device instance _108_t4 r0 *1 0,0
R_108_t4 \$108__t4 \$108 16.7641747213
* device instance _108 r0 *1 0,0
C_108 \$108 vsubs 7.92193e-16
* device instance _109_t0 r0 *1 0,0
R_109_t0 \$109__t0 \$109 14.0706287935
* device instance _109_t1 r0 *1 0,0
R_109_t1 \$109__t1 \$109 17.162141452
* device instance _109_t2 r0 *1 0,0
R_109_t2 \$109__t2 \$109 13.6875065396
* device instance _109_t3 r0 *1 0,0
R_109_t3 \$109__t3 \$109 9.52844849363
* device instance _109_t4 r0 *1 0,0
R_109_t4 \$109__t4 \$109 16.7641747213
* device instance _109 r0 *1 0,0
C_109 \$109 vsubs 7.92193e-16
* device instance _11_t0 r0 *1 0,0
R_11_t0 \$11__t0 \$11 14.0706287935
* device instance _11_t1 r0 *1 0,0
R_11_t1 \$11__t1 \$11 17.162141452
* device instance _11_t2 r0 *1 0,0
R_11_t2 \$11__t2 \$11 13.6875065396
* device instance _11_t3 r0 *1 0,0
R_11_t3 \$11__t3 \$11 9.52844849363
* device instance _11_t4 r0 *1 0,0
R_11_t4 \$11__t4 \$11 16.7641747213
* device instance _11 r0 *1 0,0
C_11 \$11 vsubs 7.92193e-16
* device instance _110_t0 r0 *1 0,0
R_110_t0 \$110__t0 \$110 14.0706287935
* device instance _110_t1 r0 *1 0,0
R_110_t1 \$110__t1 \$110 17.162141452
* device instance _110_t2 r0 *1 0,0
R_110_t2 \$110__t2 \$110 13.6875065396
* device instance _110_t3 r0 *1 0,0
R_110_t3 \$110__t3 \$110 9.52844849363
* device instance _110_t4 r0 *1 0,0
R_110_t4 \$110__t4 \$110 16.7641747213
* device instance _110 r0 *1 0,0
C_110 \$110 vsubs 7.92193e-16
* device instance _111_t0 r0 *1 0,0
R_111_t0 \$111__t0 \$111 14.0706287935
* device instance _111_t1 r0 *1 0,0
R_111_t1 \$111__t1 \$111 17.162141452
* device instance _111_t2 r0 *1 0,0
R_111_t2 \$111__t2 \$111 13.6875065396
* device instance _111_t3 r0 *1 0,0
R_111_t3 \$111__t3 \$111 9.52844849363
* device instance _111_t4 r0 *1 0,0
R_111_t4 \$111__t4 \$111 16.7641747213
* device instance _111 r0 *1 0,0
C_111 \$111 vsubs 7.92193e-16
* device instance _112_t0 r0 *1 0,0
R_112_t0 \$112__t0 \$112 14.0706287935
* device instance _112_t1 r0 *1 0,0
R_112_t1 \$112__t1 \$112 17.162141452
* device instance _112_t2 r0 *1 0,0
R_112_t2 \$112__t2 \$112 13.6875065396
* device instance _112_t3 r0 *1 0,0
R_112_t3 \$112__t3 \$112 9.52844849363
* device instance _112_t4 r0 *1 0,0
R_112_t4 \$112__t4 \$112 16.7641747213
* device instance _112 r0 *1 0,0
C_112 \$112 vsubs 7.92193e-16
* device instance _113_t0 r0 *1 0,0
R_113_t0 \$113__t0 \$113 14.0706287935
* device instance _113_t1 r0 *1 0,0
R_113_t1 \$113__t1 \$113 17.162141452
* device instance _113_t2 r0 *1 0,0
R_113_t2 \$113__t2 \$113 13.6875065396
* device instance _113_t3 r0 *1 0,0
R_113_t3 \$113__t3 \$113 9.52844849363
* device instance _113_t4 r0 *1 0,0
R_113_t4 \$113__t4 \$113 16.7641747213
* device instance _113 r0 *1 0,0
C_113 \$113 vsubs 7.92193e-16
* device instance _114_t0 r0 *1 0,0
R_114_t0 \$114__t0 \$114 14.0706287935
* device instance _114_t1 r0 *1 0,0
R_114_t1 \$114__t1 \$114 17.162141452
* device instance _114_t2 r0 *1 0,0
R_114_t2 \$114__t2 \$114 13.6875065396
* device instance _114_t3 r0 *1 0,0
R_114_t3 \$114__t3 \$114 9.52844849363
* device instance _114_t4 r0 *1 0,0
R_114_t4 \$114__t4 \$114 16.7641747213
* device instance _114 r0 *1 0,0
C_114 \$114 vsubs 7.92193e-16
* device instance _115_t0 r0 *1 0,0
R_115_t0 \$115__t0 \$115 14.0706287935
* device instance _115_t1 r0 *1 0,0
R_115_t1 \$115__t1 \$115 17.162141452
* device instance _115_t2 r0 *1 0,0
R_115_t2 \$115__t2 \$115 13.6875065396
* device instance _115_t3 r0 *1 0,0
R_115_t3 \$115__t3 \$115 9.52844849363
* device instance _115_t4 r0 *1 0,0
R_115_t4 \$115__t4 \$115 16.7641747213
* device instance _115 r0 *1 0,0
C_115 \$115 vsubs 7.92193e-16
* device instance _116_t0 r0 *1 0,0
R_116_t0 \$116__t0 \$116 14.0706287935
* device instance _116_t1 r0 *1 0,0
R_116_t1 \$116__t1 \$116 17.162141452
* device instance _116_t2 r0 *1 0,0
R_116_t2 \$116__t2 \$116 13.6875065396
* device instance _116_t3 r0 *1 0,0
R_116_t3 \$116__t3 \$116 9.52844849363
* device instance _116_t4 r0 *1 0,0
R_116_t4 \$116__t4 \$116 16.7641747213
* device instance _116 r0 *1 0,0
C_116 \$116 vsubs 7.92193e-16
* device instance _117_t0 r0 *1 0,0
R_117_t0 \$117__t0 \$117 14.0706287935
* device instance _117_t1 r0 *1 0,0
R_117_t1 \$117__t1 \$117 17.162141452
* device instance _117_t2 r0 *1 0,0
R_117_t2 \$117__t2 \$117 13.6875065396
* device instance _117_t3 r0 *1 0,0
R_117_t3 \$117__t3 \$117 9.52844849363
* device instance _117_t4 r0 *1 0,0
R_117_t4 \$117__t4 \$117 16.7641747213
* device instance _117 r0 *1 0,0
C_117 \$117 vsubs 7.92193e-16
* device instance _118_t0 r0 *1 0,0
R_118_t0 \$118__t0 \$118 14.0706287935
* device instance _118_t1 r0 *1 0,0
R_118_t1 \$118__t1 \$118 17.162141452
* device instance _118_t2 r0 *1 0,0
R_118_t2 \$118__t2 \$118 13.6875065396
* device instance _118_t3 r0 *1 0,0
R_118_t3 \$118__t3 \$118 9.52844849363
* device instance _118_t4 r0 *1 0,0
R_118_t4 \$118__t4 \$118 16.7641747213
* device instance _118 r0 *1 0,0
C_118 \$118 vsubs 7.92193e-16
* device instance _119_t0 r0 *1 0,0
R_119_t0 \$119__t0 \$119 14.0706287935
* device instance _119_t1 r0 *1 0,0
R_119_t1 \$119__t1 \$119 17.162141452
* device instance _119_t2 r0 *1 0,0
R_119_t2 \$119__t2 \$119 13.6875065396
* device instance _119_t3 r0 *1 0,0
R_119_t3 \$119__t3 \$119 9.52844849363
* device instance _119_t4 r0 *1 0,0
R_119_t4 \$119__t4 \$119 16.7641747213
* device instance _119 r0 *1 0,0
C_119 \$119 vsubs 7.92193e-16
* device instance _12_t0 r0 *1 0,0
R_12_t0 \$12__t0 \$12 14.0706287935
* device instance _12_t1 r0 *1 0,0
R_12_t1 \$12__t1 \$12 17.162141452
* device instance _12_t2 r0 *1 0,0
R_12_t2 \$12__t2 \$12 13.6875065396
* device instance _12_t3 r0 *1 0,0
R_12_t3 \$12__t3 \$12 9.52844849363
* device instance _12_t4 r0 *1 0,0
R_12_t4 \$12__t4 \$12 16.7641747213
* device instance _12 r0 *1 0,0
C_12 \$12 vsubs 7.92193e-16
* device instance _120_t0 r0 *1 0,0
R_120_t0 \$120__t0 \$120 14.0706287935
* device instance _120_t1 r0 *1 0,0
R_120_t1 \$120__t1 \$120 17.162141452
* device instance _120_t2 r0 *1 0,0
R_120_t2 \$120__t2 \$120 13.6875065396
* device instance _120_t3 r0 *1 0,0
R_120_t3 \$120__t3 \$120 9.52844849363
* device instance _120_t4 r0 *1 0,0
R_120_t4 \$120__t4 \$120 16.7641747213
* device instance _120 r0 *1 0,0
C_120 \$120 vsubs 7.92193e-16
* device instance _121_t0 r0 *1 0,0
R_121_t0 \$121__t0 \$121 14.0706287935
* device instance _121_t1 r0 *1 0,0
R_121_t1 \$121__t1 \$121 17.162141452
* device instance _121_t2 r0 *1 0,0
R_121_t2 \$121__t2 \$121 13.6875065396
* device instance _121_t3 r0 *1 0,0
R_121_t3 \$121__t3 \$121 9.52844849363
* device instance _121_t4 r0 *1 0,0
R_121_t4 \$121__t4 \$121 16.7641747213
* device instance _121 r0 *1 0,0
C_121 \$121 vsubs 7.92193e-16
* device instance _122_t0 r0 *1 0,0
R_122_t0 \$122__t0 \$122 14.0706287935
* device instance _122_t1 r0 *1 0,0
R_122_t1 \$122__t1 \$122 17.162141452
* device instance _122_t2 r0 *1 0,0
R_122_t2 \$122__t2 \$122 13.6875065396
* device instance _122_t3 r0 *1 0,0
R_122_t3 \$122__t3 \$122 9.52844849363
* device instance _122_t4 r0 *1 0,0
R_122_t4 \$122__t4 \$122 16.7641747213
* device instance _122 r0 *1 0,0
C_122 \$122 vsubs 7.92193e-16
* device instance _123_t0 r0 *1 0,0
R_123_t0 \$123__t0 \$123 14.0706287935
* device instance _123_t1 r0 *1 0,0
R_123_t1 \$123__t1 \$123 17.162141452
* device instance _123_t2 r0 *1 0,0
R_123_t2 \$123__t2 \$123 13.6875065396
* device instance _123_t3 r0 *1 0,0
R_123_t3 \$123__t3 \$123 9.52844849363
* device instance _123_t4 r0 *1 0,0
R_123_t4 \$123__t4 \$123 16.7641747213
* device instance _123 r0 *1 0,0
C_123 \$123 vsubs 7.92193e-16
* device instance _124_t0 r0 *1 0,0
R_124_t0 \$124__t0 \$124 14.0706287935
* device instance _124_t1 r0 *1 0,0
R_124_t1 \$124__t1 \$124 17.162141452
* device instance _124_t2 r0 *1 0,0
R_124_t2 \$124__t2 \$124 13.6875065396
* device instance _124_t3 r0 *1 0,0
R_124_t3 \$124__t3 \$124 9.52844849363
* device instance _124_t4 r0 *1 0,0
R_124_t4 \$124__t4 \$124 16.7641747213
* device instance _124 r0 *1 0,0
C_124 \$124 vsubs 7.92193e-16
* device instance _125_t0 r0 *1 0,0
R_125_t0 \$125__t0 \$125 14.0706287935
* device instance _125_t1 r0 *1 0,0
R_125_t1 \$125__t1 \$125 17.162141452
* device instance _125_t2 r0 *1 0,0
R_125_t2 \$125__t2 \$125 13.6875065396
* device instance _125_t3 r0 *1 0,0
R_125_t3 \$125__t3 \$125 9.52844849363
* device instance _125_t4 r0 *1 0,0
R_125_t4 \$125__t4 \$125 16.7641747213
* device instance _125 r0 *1 0,0
C_125 \$125 vsubs 7.92193e-16
* device instance _126_t0 r0 *1 0,0
R_126_t0 \$126__t0 \$126 14.0706287935
* device instance _126_t1 r0 *1 0,0
R_126_t1 \$126__t1 \$126 17.162141452
* device instance _126_t2 r0 *1 0,0
R_126_t2 \$126__t2 \$126 13.6875065396
* device instance _126_t3 r0 *1 0,0
R_126_t3 \$126__t3 \$126 9.52844849363
* device instance _126_t4 r0 *1 0,0
R_126_t4 \$126__t4 \$126 16.7641747213
* device instance _126 r0 *1 0,0
C_126 \$126 vsubs 7.92193e-16
* device instance _127_t0 r0 *1 0,0
R_127_t0 \$127__t0 \$127 14.0706287935
* device instance _127_t1 r0 *1 0,0
R_127_t1 \$127__t1 \$127 17.162141452
* device instance _127_t2 r0 *1 0,0
R_127_t2 \$127__t2 \$127 13.6875065396
* device instance _127_t3 r0 *1 0,0
R_127_t3 \$127__t3 \$127 9.52844849363
* device instance _127_t4 r0 *1 0,0
R_127_t4 \$127__t4 \$127 16.7641747213
* device instance _127 r0 *1 0,0
C_127 \$127 vsubs 7.92193e-16
* device instance _128_t0 r0 *1 0,0
R_128_t0 \$128__t0 \$128 14.0706287935
* device instance _128_t1 r0 *1 0,0
R_128_t1 \$128__t1 \$128 17.162141452
* device instance _128_t2 r0 *1 0,0
R_128_t2 \$128__t2 \$128 13.6875065396
* device instance _128_t3 r0 *1 0,0
R_128_t3 \$128__t3 \$128 9.52844849363
* device instance _128_t4 r0 *1 0,0
R_128_t4 \$128__t4 \$128 16.7641747213
* device instance _128 r0 *1 0,0
C_128 \$128 vsubs 7.92193e-16
* device instance _129_t0 r0 *1 0,0
R_129_t0 \$129__t0 \$129 14.0706287935
* device instance _129_t1 r0 *1 0,0
R_129_t1 \$129__t1 \$129 17.162141452
* device instance _129_t2 r0 *1 0,0
R_129_t2 \$129__t2 \$129 13.6875065396
* device instance _129_t3 r0 *1 0,0
R_129_t3 \$129__t3 \$129 9.52844849363
* device instance _129_t4 r0 *1 0,0
R_129_t4 \$129__t4 \$129 16.7641747213
* device instance _129 r0 *1 0,0
C_129 \$129 vsubs 7.92193e-16
* device instance _13_t0 r0 *1 0,0
R_13_t0 \$13__t0 \$13 14.0706287935
* device instance _13_t1 r0 *1 0,0
R_13_t1 \$13__t1 \$13 17.162141452
* device instance _13_t2 r0 *1 0,0
R_13_t2 \$13__t2 \$13 13.6875065396
* device instance _13_t3 r0 *1 0,0
R_13_t3 \$13__t3 \$13 9.52844849363
* device instance _13_t4 r0 *1 0,0
R_13_t4 \$13__t4 \$13 16.7641747213
* device instance _13 r0 *1 0,0
C_13 \$13 vsubs 7.92193e-16
* device instance _130_t0 r0 *1 0,0
R_130_t0 \$130__t0 \$130 14.0706287935
* device instance _130_t1 r0 *1 0,0
R_130_t1 \$130__t1 \$130 17.162141452
* device instance _130_t2 r0 *1 0,0
R_130_t2 \$130__t2 \$130 13.6875065396
* device instance _130_t3 r0 *1 0,0
R_130_t3 \$130__t3 \$130 9.52844849363
* device instance _130_t4 r0 *1 0,0
R_130_t4 \$130__t4 \$130 16.7641747213
* device instance _130 r0 *1 0,0
C_130 \$130 vsubs 7.92193e-16
* device instance _131_t0 r0 *1 0,0
R_131_t0 \$131__t0 \$131 14.0706287935
* device instance _131_t1 r0 *1 0,0
R_131_t1 \$131__t1 \$131 17.162141452
* device instance _131_t2 r0 *1 0,0
R_131_t2 \$131__t2 \$131 13.6875065396
* device instance _131_t3 r0 *1 0,0
R_131_t3 \$131__t3 \$131 9.52844849363
* device instance _131_t4 r0 *1 0,0
R_131_t4 \$131__t4 \$131 16.7641747213
* device instance _131 r0 *1 0,0
C_131 \$131 vsubs 7.92193e-16
* device instance _133_t0 r0 *1 0,0
R_133_t0 \$133__t0 \$133 13.6875065396
* device instance _133_t1 r0 *1 0,0
R_133_t1 \$133__t1 \$133 14.0706287935
* device instance _133_t2 r0 *1 0,0
R_133_t2 \$133__t2 \$133 17.162141452
* device instance _133_t3 r0 *1 0,0
R_133_t3 \$133__t3 \$133 9.52844849363
* device instance _133_t4 r0 *1 0,0
R_133_t4 \$133__t4 \$133 16.7641747213
* device instance _133 r0 *1 0,0
C_133 \$133 vsubs 7.83841e-16
* device instance _136_t0 r0 *1 0,0
R_136_t0 \$136__t0 \$136 17.162141452
* device instance _136_t1 r0 *1 0,0
R_136_t1 \$136__t1 \$136 14.0706287935
* device instance _136_t2 r0 *1 0,0
R_136_t2 \$136__t2 \$136 13.6875065396
* device instance _136_t3 r0 *1 0,0
R_136_t3 \$136__t3 \$136 16.7641747213
* device instance _136_t4 r0 *1 0,0
R_136_t4 \$136__t4 \$136 9.52844849363
* device instance _136 r0 *1 0,0
C_136 \$136 vsubs 7.83841e-16
* device instance _139_t0 r0 *1 0,0
R_139_t0 \$139__t0 \$139 17.162141452
* device instance _139_t1 r0 *1 0,0
R_139_t1 \$139__t1 \$139 14.0706287935
* device instance _139_t2 r0 *1 0,0
R_139_t2 \$139__t2 \$139 13.6875065396
* device instance _139_t3 r0 *1 0,0
R_139_t3 \$139__t3 \$139 16.7641747213
* device instance _139_t4 r0 *1 0,0
R_139_t4 \$139__t4 \$139 9.52844849363
* device instance _139 r0 *1 0,0
C_139 \$139 vsubs 7.83841e-16
* device instance _14_t0 r0 *1 0,0
R_14_t0 \$14__t0 \$14 14.0706287935
* device instance _14_t1 r0 *1 0,0
R_14_t1 \$14__t1 \$14 17.162141452
* device instance _14_t2 r0 *1 0,0
R_14_t2 \$14__t2 \$14 13.6875065396
* device instance _14_t3 r0 *1 0,0
R_14_t3 \$14__t3 \$14 9.52844849363
* device instance _14_t4 r0 *1 0,0
R_14_t4 \$14__t4 \$14 16.7641747213
* device instance _14 r0 *1 0,0
C_14 \$14 vsubs 7.92193e-16
* device instance _142_t0 r0 *1 0,0
R_142_t0 \$142__t0 \$142 17.162141452
* device instance _142_t1 r0 *1 0,0
R_142_t1 \$142__t1 \$142 14.0706287935
* device instance _142_t2 r0 *1 0,0
R_142_t2 \$142__t2 \$142 13.6875065396
* device instance _142_t3 r0 *1 0,0
R_142_t3 \$142__t3 \$142 16.7641747213
* device instance _142_t4 r0 *1 0,0
R_142_t4 \$142__t4 \$142 9.52844849363
* device instance _142 r0 *1 0,0
C_142 \$142 vsubs 7.83841e-16
* device instance _145_t0 r0 *1 0,0
R_145_t0 \$145__t0 \$145 17.162141452
* device instance _145_t1 r0 *1 0,0
R_145_t1 \$145__t1 \$145 14.0706287935
* device instance _145_t2 r0 *1 0,0
R_145_t2 \$145__t2 \$145 13.6875065396
* device instance _145_t3 r0 *1 0,0
R_145_t3 \$145__t3 \$145 16.7641747213
* device instance _145_t4 r0 *1 0,0
R_145_t4 \$145__t4 \$145 9.52844849363
* device instance _145 r0 *1 0,0
C_145 \$145 vsubs 7.83841e-16
* device instance _148_t0 r0 *1 0,0
R_148_t0 \$148__t0 \$148 17.162141452
* device instance _148_t1 r0 *1 0,0
R_148_t1 \$148__t1 \$148 14.0706287935
* device instance _148_t2 r0 *1 0,0
R_148_t2 \$148__t2 \$148 13.6875065396
* device instance _148_t3 r0 *1 0,0
R_148_t3 \$148__t3 \$148 16.7641747213
* device instance _148_t4 r0 *1 0,0
R_148_t4 \$148__t4 \$148 9.52844849363
* device instance _148 r0 *1 0,0
C_148 \$148 vsubs 7.83841e-16
* device instance _15_t0 r0 *1 0,0
R_15_t0 \$15__t0 \$15 14.0706287935
* device instance _15_t1 r0 *1 0,0
R_15_t1 \$15__t1 \$15 17.162141452
* device instance _15_t2 r0 *1 0,0
R_15_t2 \$15__t2 \$15 13.6875065396
* device instance _15_t3 r0 *1 0,0
R_15_t3 \$15__t3 \$15 9.52844849363
* device instance _15_t4 r0 *1 0,0
R_15_t4 \$15__t4 \$15 16.7641747213
* device instance _15 r0 *1 0,0
C_15 \$15 vsubs 7.92193e-16
* device instance _151_t0 r0 *1 0,0
R_151_t0 \$151__t0 \$151 17.162141452
* device instance _151_t1 r0 *1 0,0
R_151_t1 \$151__t1 \$151 14.0706287935
* device instance _151_t2 r0 *1 0,0
R_151_t2 \$151__t2 \$151 13.6875065396
* device instance _151_t3 r0 *1 0,0
R_151_t3 \$151__t3 \$151 16.7641747213
* device instance _151_t4 r0 *1 0,0
R_151_t4 \$151__t4 \$151 9.52844849363
* device instance _151 r0 *1 0,0
C_151 \$151 vsubs 7.83841e-16
* device instance _154_t0 r0 *1 0,0
R_154_t0 \$154__t0 \$154 17.162141452
* device instance _154_t1 r0 *1 0,0
R_154_t1 \$154__t1 \$154 14.0706287935
* device instance _154_t2 r0 *1 0,0
R_154_t2 \$154__t2 \$154 13.6875065396
* device instance _154_t3 r0 *1 0,0
R_154_t3 \$154__t3 \$154 16.7641747213
* device instance _154_t4 r0 *1 0,0
R_154_t4 \$154__t4 \$154 9.52844849363
* device instance _154 r0 *1 0,0
C_154 \$154 vsubs 7.83841e-16
* device instance _157_t0 r0 *1 0,0
R_157_t0 \$157__t0 \$157 17.162141452
* device instance _157_t1 r0 *1 0,0
R_157_t1 \$157__t1 \$157 14.0706287935
* device instance _157_t2 r0 *1 0,0
R_157_t2 \$157__t2 \$157 13.6875065396
* device instance _157_t3 r0 *1 0,0
R_157_t3 \$157__t3 \$157 16.7641747213
* device instance _157_t4 r0 *1 0,0
R_157_t4 \$157__t4 \$157 9.52844849363
* device instance _157 r0 *1 0,0
C_157 \$157 vsubs 7.83841e-16
* device instance _16_t0 r0 *1 0,0
R_16_t0 \$16__t0 \$16 14.0706287935
* device instance _16_t1 r0 *1 0,0
R_16_t1 \$16__t1 \$16 17.162141452
* device instance _16_t2 r0 *1 0,0
R_16_t2 \$16__t2 \$16 13.6875065396
* device instance _16_t3 r0 *1 0,0
R_16_t3 \$16__t3 \$16 9.52844849363
* device instance _16_t4 r0 *1 0,0
R_16_t4 \$16__t4 \$16 16.7641747213
* device instance _16 r0 *1 0,0
C_16 \$16 vsubs 7.92193e-16
* device instance _160_t0 r0 *1 0,0
R_160_t0 \$160__t0 \$160 17.162141452
* device instance _160_t1 r0 *1 0,0
R_160_t1 \$160__t1 \$160 14.0706287935
* device instance _160_t2 r0 *1 0,0
R_160_t2 \$160__t2 \$160 13.6875065396
* device instance _160_t3 r0 *1 0,0
R_160_t3 \$160__t3 \$160 16.7641747213
* device instance _160_t4 r0 *1 0,0
R_160_t4 \$160__t4 \$160 9.52844849363
* device instance _160 r0 *1 0,0
C_160 \$160 vsubs 7.83841e-16
* device instance _163_t0 r0 *1 0,0
R_163_t0 \$163__t0 \$163 17.162141452
* device instance _163_t1 r0 *1 0,0
R_163_t1 \$163__t1 \$163 14.0706287935
* device instance _163_t2 r0 *1 0,0
R_163_t2 \$163__t2 \$163 13.6875065396
* device instance _163_t3 r0 *1 0,0
R_163_t3 \$163__t3 \$163 16.7641747213
* device instance _163_t4 r0 *1 0,0
R_163_t4 \$163__t4 \$163 9.52844849363
* device instance _163 r0 *1 0,0
C_163 \$163 vsubs 7.83841e-16
* device instance _166_t0 r0 *1 0,0
R_166_t0 \$166__t0 \$166 17.162141452
* device instance _166_t1 r0 *1 0,0
R_166_t1 \$166__t1 \$166 14.0706287935
* device instance _166_t2 r0 *1 0,0
R_166_t2 \$166__t2 \$166 13.6875065396
* device instance _166_t3 r0 *1 0,0
R_166_t3 \$166__t3 \$166 16.7641747213
* device instance _166_t4 r0 *1 0,0
R_166_t4 \$166__t4 \$166 9.52844849363
* device instance _166 r0 *1 0,0
C_166 \$166 vsubs 7.83841e-16
* device instance _169_t0 r0 *1 0,0
R_169_t0 \$169__t0 \$169 17.162141452
* device instance _169_t1 r0 *1 0,0
R_169_t1 \$169__t1 \$169 14.0706287935
* device instance _169_t2 r0 *1 0,0
R_169_t2 \$169__t2 \$169 13.6875065396
* device instance _169_t3 r0 *1 0,0
R_169_t3 \$169__t3 \$169 16.7641747213
* device instance _169_t4 r0 *1 0,0
R_169_t4 \$169__t4 \$169 9.52844849363
* device instance _169 r0 *1 0,0
C_169 \$169 vsubs 7.83841e-16
* device instance _17_t0 r0 *1 0,0
R_17_t0 \$17__t0 \$17 14.0706287935
* device instance _17_t1 r0 *1 0,0
R_17_t1 \$17__t1 \$17 17.162141452
* device instance _17_t2 r0 *1 0,0
R_17_t2 \$17__t2 \$17 13.6875065396
* device instance _17_t3 r0 *1 0,0
R_17_t3 \$17__t3 \$17 9.52844849363
* device instance _17_t4 r0 *1 0,0
R_17_t4 \$17__t4 \$17 16.7641747213
* device instance _17 r0 *1 0,0
C_17 \$17 vsubs 7.92193e-16
* device instance _172_t0 r0 *1 0,0
R_172_t0 \$172__t0 \$172 17.162141452
* device instance _172_t1 r0 *1 0,0
R_172_t1 \$172__t1 \$172 14.0706287935
* device instance _172_t2 r0 *1 0,0
R_172_t2 \$172__t2 \$172 13.6875065396
* device instance _172_t3 r0 *1 0,0
R_172_t3 \$172__t3 \$172 16.7641747213
* device instance _172_t4 r0 *1 0,0
R_172_t4 \$172__t4 \$172 9.52844849363
* device instance _172 r0 *1 0,0
C_172 \$172 vsubs 7.83841e-16
* device instance _175_t0 r0 *1 0,0
R_175_t0 \$175__t0 \$175 17.162141452
* device instance _175_t1 r0 *1 0,0
R_175_t1 \$175__t1 \$175 14.0706287935
* device instance _175_t2 r0 *1 0,0
R_175_t2 \$175__t2 \$175 13.6875065396
* device instance _175_t3 r0 *1 0,0
R_175_t3 \$175__t3 \$175 16.7641747213
* device instance _175_t4 r0 *1 0,0
R_175_t4 \$175__t4 \$175 9.52844849363
* device instance _175 r0 *1 0,0
C_175 \$175 vsubs 7.83841e-16
* device instance _178_t0 r0 *1 0,0
R_178_t0 \$178__t0 \$178 17.162141452
* device instance _178_t1 r0 *1 0,0
R_178_t1 \$178__t1 \$178 14.0706287935
* device instance _178_t2 r0 *1 0,0
R_178_t2 \$178__t2 \$178 13.6875065396
* device instance _178_t3 r0 *1 0,0
R_178_t3 \$178__t3 \$178 16.7641747213
* device instance _178_t4 r0 *1 0,0
R_178_t4 \$178__t4 \$178 9.52844849363
* device instance _178 r0 *1 0,0
C_178 \$178 vsubs 7.83841e-16
* device instance _18_t0 r0 *1 0,0
R_18_t0 \$18__t0 \$18 14.0706287935
* device instance _18_t1 r0 *1 0,0
R_18_t1 \$18__t1 \$18 17.162141452
* device instance _18_t2 r0 *1 0,0
R_18_t2 \$18__t2 \$18 13.6875065396
* device instance _18_t3 r0 *1 0,0
R_18_t3 \$18__t3 \$18 9.52844849363
* device instance _18_t4 r0 *1 0,0
R_18_t4 \$18__t4 \$18 16.7641747213
* device instance _18 r0 *1 0,0
C_18 \$18 vsubs 7.92193e-16
* device instance _181_t0 r0 *1 0,0
R_181_t0 \$181__t0 \$181 17.162141452
* device instance _181_t1 r0 *1 0,0
R_181_t1 \$181__t1 \$181 14.0706287935
* device instance _181_t2 r0 *1 0,0
R_181_t2 \$181__t2 \$181 13.6875065396
* device instance _181_t3 r0 *1 0,0
R_181_t3 \$181__t3 \$181 16.7641747213
* device instance _181_t4 r0 *1 0,0
R_181_t4 \$181__t4 \$181 9.52844849363
* device instance _181 r0 *1 0,0
C_181 \$181 vsubs 7.83841e-16
* device instance _184_t0 r0 *1 0,0
R_184_t0 \$184__t0 \$184 17.162141452
* device instance _184_t1 r0 *1 0,0
R_184_t1 \$184__t1 \$184 14.0706287935
* device instance _184_t2 r0 *1 0,0
R_184_t2 \$184__t2 \$184 13.6875065396
* device instance _184_t3 r0 *1 0,0
R_184_t3 \$184__t3 \$184 16.7641747213
* device instance _184_t4 r0 *1 0,0
R_184_t4 \$184__t4 \$184 9.52844849363
* device instance _184 r0 *1 0,0
C_184 \$184 vsubs 7.83841e-16
* device instance _187_t0 r0 *1 0,0
R_187_t0 \$187__t0 \$187 17.162141452
* device instance _187_t1 r0 *1 0,0
R_187_t1 \$187__t1 \$187 14.0706287935
* device instance _187_t2 r0 *1 0,0
R_187_t2 \$187__t2 \$187 13.6875065396
* device instance _187_t3 r0 *1 0,0
R_187_t3 \$187__t3 \$187 16.7641747213
* device instance _187_t4 r0 *1 0,0
R_187_t4 \$187__t4 \$187 9.52844849363
* device instance _187 r0 *1 0,0
C_187 \$187 vsubs 7.83841e-16
* device instance _19_t0 r0 *1 0,0
R_19_t0 \$19__t0 \$19 14.0706287935
* device instance _19_t1 r0 *1 0,0
R_19_t1 \$19__t1 \$19 17.162141452
* device instance _19_t2 r0 *1 0,0
R_19_t2 \$19__t2 \$19 13.6875065396
* device instance _19_t3 r0 *1 0,0
R_19_t3 \$19__t3 \$19 9.52844849363
* device instance _19_t4 r0 *1 0,0
R_19_t4 \$19__t4 \$19 16.7641747213
* device instance _19 r0 *1 0,0
C_19 \$19 vsubs 7.92193e-16
* device instance _190_t0 r0 *1 0,0
R_190_t0 \$190__t0 \$190 17.162141452
* device instance _190_t1 r0 *1 0,0
R_190_t1 \$190__t1 \$190 14.0706287935
* device instance _190_t2 r0 *1 0,0
R_190_t2 \$190__t2 \$190 13.6875065396
* device instance _190_t3 r0 *1 0,0
R_190_t3 \$190__t3 \$190 16.7641747213
* device instance _190_t4 r0 *1 0,0
R_190_t4 \$190__t4 \$190 9.52844849363
* device instance _190 r0 *1 0,0
C_190 \$190 vsubs 7.83841e-16
* device instance _193_t0 r0 *1 0,0
R_193_t0 \$193__t0 \$193 17.162141452
* device instance _193_t1 r0 *1 0,0
R_193_t1 \$193__t1 \$193 14.0706287935
* device instance _193_t2 r0 *1 0,0
R_193_t2 \$193__t2 \$193 13.6875065396
* device instance _193_t3 r0 *1 0,0
R_193_t3 \$193__t3 \$193 16.7641747213
* device instance _193_t4 r0 *1 0,0
R_193_t4 \$193__t4 \$193 9.52844849363
* device instance _193 r0 *1 0,0
C_193 \$193 vsubs 7.83841e-16
* device instance _196_t0 r0 *1 0,0
R_196_t0 \$196__t0 \$196 17.162141452
* device instance _196_t1 r0 *1 0,0
R_196_t1 \$196__t1 \$196 14.0706287935
* device instance _196_t2 r0 *1 0,0
R_196_t2 \$196__t2 \$196 13.6875065396
* device instance _196_t3 r0 *1 0,0
R_196_t3 \$196__t3 \$196 16.7641747213
* device instance _196_t4 r0 *1 0,0
R_196_t4 \$196__t4 \$196 9.52844849363
* device instance _196 r0 *1 0,0
C_196 \$196 vsubs 7.83841e-16
* device instance _199_t0 r0 *1 0,0
R_199_t0 \$199__t0 \$199 17.162141452
* device instance _199_t1 r0 *1 0,0
R_199_t1 \$199__t1 \$199 14.0706287935
* device instance _199_t2 r0 *1 0,0
R_199_t2 \$199__t2 \$199 13.6875065396
* device instance _199_t3 r0 *1 0,0
R_199_t3 \$199__t3 \$199 16.7641747213
* device instance _199_t4 r0 *1 0,0
R_199_t4 \$199__t4 \$199 9.52844849363
* device instance _199 r0 *1 0,0
C_199 \$199 vsubs 7.83841e-16
* device instance _20_t0 r0 *1 0,0
R_20_t0 \$20__t0 \$20 14.0706287935
* device instance _20_t1 r0 *1 0,0
R_20_t1 \$20__t1 \$20 17.162141452
* device instance _20_t2 r0 *1 0,0
R_20_t2 \$20__t2 \$20 13.6875065396
* device instance _20_t3 r0 *1 0,0
R_20_t3 \$20__t3 \$20 9.52844849363
* device instance _20_t4 r0 *1 0,0
R_20_t4 \$20__t4 \$20 16.7641747213
* device instance _20 r0 *1 0,0
C_20 \$20 vsubs 7.92193e-16
* device instance _202_t0 r0 *1 0,0
R_202_t0 \$202__t0 \$202 17.162141452
* device instance _202_t1 r0 *1 0,0
R_202_t1 \$202__t1 \$202 14.0706287935
* device instance _202_t2 r0 *1 0,0
R_202_t2 \$202__t2 \$202 13.6875065396
* device instance _202_t3 r0 *1 0,0
R_202_t3 \$202__t3 \$202 16.7641747213
* device instance _202_t4 r0 *1 0,0
R_202_t4 \$202__t4 \$202 9.52844849363
* device instance _202 r0 *1 0,0
C_202 \$202 vsubs 7.83841e-16
* device instance _205_t0 r0 *1 0,0
R_205_t0 \$205__t0 \$205 17.162141452
* device instance _205_t1 r0 *1 0,0
R_205_t1 \$205__t1 \$205 14.0706287935
* device instance _205_t2 r0 *1 0,0
R_205_t2 \$205__t2 \$205 13.6875065396
* device instance _205_t3 r0 *1 0,0
R_205_t3 \$205__t3 \$205 16.7641747213
* device instance _205_t4 r0 *1 0,0
R_205_t4 \$205__t4 \$205 9.52844849363
* device instance _205 r0 *1 0,0
C_205 \$205 vsubs 7.83841e-16
* device instance _208_t0 r0 *1 0,0
R_208_t0 \$208__t0 \$208 17.162141452
* device instance _208_t1 r0 *1 0,0
R_208_t1 \$208__t1 \$208 14.0706287935
* device instance _208_t2 r0 *1 0,0
R_208_t2 \$208__t2 \$208 13.6875065396
* device instance _208_t3 r0 *1 0,0
R_208_t3 \$208__t3 \$208 16.7641747213
* device instance _208_t4 r0 *1 0,0
R_208_t4 \$208__t4 \$208 9.52844849363
* device instance _208 r0 *1 0,0
C_208 \$208 vsubs 7.83841e-16
* device instance _21_t0 r0 *1 0,0
R_21_t0 \$21__t0 \$21 14.0706287935
* device instance _21_t1 r0 *1 0,0
R_21_t1 \$21__t1 \$21 17.162141452
* device instance _21_t2 r0 *1 0,0
R_21_t2 \$21__t2 \$21 13.6875065396
* device instance _21_t3 r0 *1 0,0
R_21_t3 \$21__t3 \$21 9.52844849363
* device instance _21_t4 r0 *1 0,0
R_21_t4 \$21__t4 \$21 16.7641747213
* device instance _21 r0 *1 0,0
C_21 \$21 vsubs 7.92193e-16
* device instance _211_t0 r0 *1 0,0
R_211_t0 \$211__t0 \$211 17.162141452
* device instance _211_t1 r0 *1 0,0
R_211_t1 \$211__t1 \$211 14.0706287935
* device instance _211_t2 r0 *1 0,0
R_211_t2 \$211__t2 \$211 13.6875065396
* device instance _211_t3 r0 *1 0,0
R_211_t3 \$211__t3 \$211 16.7641747213
* device instance _211_t4 r0 *1 0,0
R_211_t4 \$211__t4 \$211 9.52844849363
* device instance _211 r0 *1 0,0
C_211 \$211 vsubs 7.83841e-16
* device instance _214_t0 r0 *1 0,0
R_214_t0 \$214__t0 \$214 17.162141452
* device instance _214_t1 r0 *1 0,0
R_214_t1 \$214__t1 \$214 14.0706287935
* device instance _214_t2 r0 *1 0,0
R_214_t2 \$214__t2 \$214 13.6875065396
* device instance _214_t3 r0 *1 0,0
R_214_t3 \$214__t3 \$214 16.7641747213
* device instance _214_t4 r0 *1 0,0
R_214_t4 \$214__t4 \$214 9.52844849363
* device instance _214 r0 *1 0,0
C_214 \$214 vsubs 7.83841e-16
* device instance _217_t0 r0 *1 0,0
R_217_t0 \$217__t0 \$217 17.162141452
* device instance _217_t1 r0 *1 0,0
R_217_t1 \$217__t1 \$217 14.0706287935
* device instance _217_t2 r0 *1 0,0
R_217_t2 \$217__t2 \$217 13.6875065396
* device instance _217_t3 r0 *1 0,0
R_217_t3 \$217__t3 \$217 16.7641747213
* device instance _217_t4 r0 *1 0,0
R_217_t4 \$217__t4 \$217 9.52844849363
* device instance _217 r0 *1 0,0
C_217 \$217 vsubs 7.83841e-16
* device instance _22_t0 r0 *1 0,0
R_22_t0 \$22__t0 \$22 14.0706287935
* device instance _22_t1 r0 *1 0,0
R_22_t1 \$22__t1 \$22 17.162141452
* device instance _22_t2 r0 *1 0,0
R_22_t2 \$22__t2 \$22 13.6875065396
* device instance _22_t3 r0 *1 0,0
R_22_t3 \$22__t3 \$22 9.52844849363
* device instance _22_t4 r0 *1 0,0
R_22_t4 \$22__t4 \$22 16.7641747213
* device instance _22 r0 *1 0,0
C_22 \$22 vsubs 7.92193e-16
* device instance _220_t0 r0 *1 0,0
R_220_t0 \$220__t0 \$220 17.162141452
* device instance _220_t1 r0 *1 0,0
R_220_t1 \$220__t1 \$220 14.0706287935
* device instance _220_t2 r0 *1 0,0
R_220_t2 \$220__t2 \$220 13.6875065396
* device instance _220_t3 r0 *1 0,0
R_220_t3 \$220__t3 \$220 16.7641747213
* device instance _220_t4 r0 *1 0,0
R_220_t4 \$220__t4 \$220 9.52844849363
* device instance _220 r0 *1 0,0
C_220 \$220 vsubs 7.83841e-16
* device instance _223_t0 r0 *1 0,0
R_223_t0 \$223__t0 \$223 17.162141452
* device instance _223_t1 r0 *1 0,0
R_223_t1 \$223__t1 \$223 14.0706287935
* device instance _223_t2 r0 *1 0,0
R_223_t2 \$223__t2 \$223 13.6875065396
* device instance _223_t3 r0 *1 0,0
R_223_t3 \$223__t3 \$223 16.7641747213
* device instance _223_t4 r0 *1 0,0
R_223_t4 \$223__t4 \$223 9.52844849363
* device instance _223 r0 *1 0,0
C_223 \$223 vsubs 7.83841e-16
* device instance _226_t0 r0 *1 0,0
R_226_t0 \$226__t0 \$226 17.162141452
* device instance _226_t1 r0 *1 0,0
R_226_t1 \$226__t1 \$226 14.0706287935
* device instance _226_t2 r0 *1 0,0
R_226_t2 \$226__t2 \$226 13.6875065396
* device instance _226_t3 r0 *1 0,0
R_226_t3 \$226__t3 \$226 16.7641747213
* device instance _226_t4 r0 *1 0,0
R_226_t4 \$226__t4 \$226 9.52844849363
* device instance _226 r0 *1 0,0
C_226 \$226 vsubs 7.83841e-16
* device instance _229_t0 r0 *1 0,0
R_229_t0 \$229__t0 \$229 17.162141452
* device instance _229_t1 r0 *1 0,0
R_229_t1 \$229__t1 \$229 14.0706287935
* device instance _229_t2 r0 *1 0,0
R_229_t2 \$229__t2 \$229 13.6875065396
* device instance _229_t3 r0 *1 0,0
R_229_t3 \$229__t3 \$229 16.7641747213
* device instance _229_t4 r0 *1 0,0
R_229_t4 \$229__t4 \$229 9.52844849363
* device instance _229 r0 *1 0,0
C_229 \$229 vsubs 7.83841e-16
* device instance _23_t0 r0 *1 0,0
R_23_t0 \$23__t0 \$23 14.0706287935
* device instance _23_t1 r0 *1 0,0
R_23_t1 \$23__t1 \$23 17.162141452
* device instance _23_t2 r0 *1 0,0
R_23_t2 \$23__t2 \$23 13.6875065396
* device instance _23_t3 r0 *1 0,0
R_23_t3 \$23__t3 \$23 9.52844849363
* device instance _23_t4 r0 *1 0,0
R_23_t4 \$23__t4 \$23 16.7641747213
* device instance _23 r0 *1 0,0
C_23 \$23 vsubs 7.92193e-16
* device instance _232_t0 r0 *1 0,0
R_232_t0 \$232__t0 \$232 17.162141452
* device instance _232_t1 r0 *1 0,0
R_232_t1 \$232__t1 \$232 14.0706287935
* device instance _232_t2 r0 *1 0,0
R_232_t2 \$232__t2 \$232 13.6875065396
* device instance _232_t3 r0 *1 0,0
R_232_t3 \$232__t3 \$232 16.7641747213
* device instance _232_t4 r0 *1 0,0
R_232_t4 \$232__t4 \$232 9.52844849363
* device instance _232 r0 *1 0,0
C_232 \$232 vsubs 7.83841e-16
* device instance _235_t0 r0 *1 0,0
R_235_t0 \$235__t0 \$235 17.162141452
* device instance _235_t1 r0 *1 0,0
R_235_t1 \$235__t1 \$235 14.0706287935
* device instance _235_t2 r0 *1 0,0
R_235_t2 \$235__t2 \$235 13.6875065396
* device instance _235_t3 r0 *1 0,0
R_235_t3 \$235__t3 \$235 16.7641747213
* device instance _235_t4 r0 *1 0,0
R_235_t4 \$235__t4 \$235 9.52844849363
* device instance _235 r0 *1 0,0
C_235 \$235 vsubs 7.83841e-16
* device instance _238_t0 r0 *1 0,0
R_238_t0 \$238__t0 \$238 17.162141452
* device instance _238_t1 r0 *1 0,0
R_238_t1 \$238__t1 \$238 14.0706287935
* device instance _238_t2 r0 *1 0,0
R_238_t2 \$238__t2 \$238 13.6875065396
* device instance _238_t3 r0 *1 0,0
R_238_t3 \$238__t3 \$238 16.7641747213
* device instance _238_t4 r0 *1 0,0
R_238_t4 \$238__t4 \$238 9.52844849363
* device instance _238 r0 *1 0,0
C_238 \$238 vsubs 7.83841e-16
* device instance _24_t0 r0 *1 0,0
R_24_t0 \$24__t0 \$24 14.0706287935
* device instance _24_t1 r0 *1 0,0
R_24_t1 \$24__t1 \$24 17.162141452
* device instance _24_t2 r0 *1 0,0
R_24_t2 \$24__t2 \$24 13.6875065396
* device instance _24_t3 r0 *1 0,0
R_24_t3 \$24__t3 \$24 9.52844849363
* device instance _24_t4 r0 *1 0,0
R_24_t4 \$24__t4 \$24 16.7641747213
* device instance _24 r0 *1 0,0
C_24 \$24 vsubs 7.92193e-16
* device instance _241_t0 r0 *1 0,0
R_241_t0 \$241__t0 \$241 17.162141452
* device instance _241_t1 r0 *1 0,0
R_241_t1 \$241__t1 \$241 14.0706287935
* device instance _241_t2 r0 *1 0,0
R_241_t2 \$241__t2 \$241 13.6875065396
* device instance _241_t3 r0 *1 0,0
R_241_t3 \$241__t3 \$241 16.7641747213
* device instance _241_t4 r0 *1 0,0
R_241_t4 \$241__t4 \$241 9.52844849363
* device instance _241 r0 *1 0,0
C_241 \$241 vsubs 7.83841e-16
* device instance _244_t0 r0 *1 0,0
R_244_t0 \$244__t0 \$244 17.162141452
* device instance _244_t1 r0 *1 0,0
R_244_t1 \$244__t1 \$244 14.0706287935
* device instance _244_t2 r0 *1 0,0
R_244_t2 \$244__t2 \$244 13.6875065396
* device instance _244_t3 r0 *1 0,0
R_244_t3 \$244__t3 \$244 16.7641747213
* device instance _244_t4 r0 *1 0,0
R_244_t4 \$244__t4 \$244 9.52844849363
* device instance _244 r0 *1 0,0
C_244 \$244 vsubs 7.83841e-16
* device instance _247_t0 r0 *1 0,0
R_247_t0 \$247__t0 \$247 17.162141452
* device instance _247_t1 r0 *1 0,0
R_247_t1 \$247__t1 \$247 14.0706287935
* device instance _247_t2 r0 *1 0,0
R_247_t2 \$247__t2 \$247 13.6875065396
* device instance _247_t3 r0 *1 0,0
R_247_t3 \$247__t3 \$247 16.7641747213
* device instance _247_t4 r0 *1 0,0
R_247_t4 \$247__t4 \$247 9.52844849363
* device instance _247 r0 *1 0,0
C_247 \$247 vsubs 7.83841e-16
* device instance _25_t0 r0 *1 0,0
R_25_t0 \$25__t0 \$25 14.0706287935
* device instance _25_t1 r0 *1 0,0
R_25_t1 \$25__t1 \$25 17.162141452
* device instance _25_t2 r0 *1 0,0
R_25_t2 \$25__t2 \$25 13.6875065396
* device instance _25_t3 r0 *1 0,0
R_25_t3 \$25__t3 \$25 9.52844849363
* device instance _25_t4 r0 *1 0,0
R_25_t4 \$25__t4 \$25 16.7641747213
* device instance _25 r0 *1 0,0
C_25 \$25 vsubs 7.92193e-16
* device instance _250_t0 r0 *1 0,0
R_250_t0 \$250__t0 \$250 17.162141452
* device instance _250_t1 r0 *1 0,0
R_250_t1 \$250__t1 \$250 14.0706287935
* device instance _250_t2 r0 *1 0,0
R_250_t2 \$250__t2 \$250 13.6875065396
* device instance _250_t3 r0 *1 0,0
R_250_t3 \$250__t3 \$250 16.7641747213
* device instance _250_t4 r0 *1 0,0
R_250_t4 \$250__t4 \$250 9.52844849363
* device instance _250 r0 *1 0,0
C_250 \$250 vsubs 7.83841e-16
* device instance _253_t0 r0 *1 0,0
R_253_t0 \$253__t0 \$253 17.162141452
* device instance _253_t1 r0 *1 0,0
R_253_t1 \$253__t1 \$253 14.0706287935
* device instance _253_t2 r0 *1 0,0
R_253_t2 \$253__t2 \$253 13.6875065396
* device instance _253_t3 r0 *1 0,0
R_253_t3 \$253__t3 \$253 16.7641747213
* device instance _253_t4 r0 *1 0,0
R_253_t4 \$253__t4 \$253 9.52844849363
* device instance _253 r0 *1 0,0
C_253 \$253 vsubs 7.83841e-16
* device instance _256_t0 r0 *1 0,0
R_256_t0 \$256__t0 \$256 17.162141452
* device instance _256_t1 r0 *1 0,0
R_256_t1 \$256__t1 \$256 14.0706287935
* device instance _256_t2 r0 *1 0,0
R_256_t2 \$256__t2 \$256 13.6875065396
* device instance _256_t3 r0 *1 0,0
R_256_t3 \$256__t3 \$256 16.7641747213
* device instance _256_t4 r0 *1 0,0
R_256_t4 \$256__t4 \$256 9.52844849363
* device instance _256 r0 *1 0,0
C_256 \$256 vsubs 7.83841e-16
* device instance _259_t0 r0 *1 0,0
R_259_t0 \$259__t0 \$259 17.162141452
* device instance _259_t1 r0 *1 0,0
R_259_t1 \$259__t1 \$259 14.0706287935
* device instance _259_t2 r0 *1 0,0
R_259_t2 \$259__t2 \$259 13.6875065396
* device instance _259_t3 r0 *1 0,0
R_259_t3 \$259__t3 \$259 16.7641747213
* device instance _259_t4 r0 *1 0,0
R_259_t4 \$259__t4 \$259 9.52844849363
* device instance _259 r0 *1 0,0
C_259 \$259 vsubs 7.83841e-16
* device instance _26_t0 r0 *1 0,0
R_26_t0 \$26__t0 \$26 14.0706287935
* device instance _26_t1 r0 *1 0,0
R_26_t1 \$26__t1 \$26 17.162141452
* device instance _26_t2 r0 *1 0,0
R_26_t2 \$26__t2 \$26 13.6875065396
* device instance _26_t3 r0 *1 0,0
R_26_t3 \$26__t3 \$26 9.52844849363
* device instance _26_t4 r0 *1 0,0
R_26_t4 \$26__t4 \$26 16.7641747213
* device instance _26 r0 *1 0,0
C_26 \$26 vsubs 7.92193e-16
* device instance _262_t0 r0 *1 0,0
R_262_t0 \$262__t0 \$262 17.162141452
* device instance _262_t1 r0 *1 0,0
R_262_t1 \$262__t1 \$262 14.0706287935
* device instance _262_t2 r0 *1 0,0
R_262_t2 \$262__t2 \$262 13.6875065396
* device instance _262_t3 r0 *1 0,0
R_262_t3 \$262__t3 \$262 16.7641747213
* device instance _262_t4 r0 *1 0,0
R_262_t4 \$262__t4 \$262 9.52844849363
* device instance _262 r0 *1 0,0
C_262 \$262 vsubs 7.83841e-16
* device instance _265_t0 r0 *1 0,0
R_265_t0 \$265__t0 \$265 17.162141452
* device instance _265_t1 r0 *1 0,0
R_265_t1 \$265__t1 \$265 14.0706287935
* device instance _265_t2 r0 *1 0,0
R_265_t2 \$265__t2 \$265 13.6875065396
* device instance _265_t3 r0 *1 0,0
R_265_t3 \$265__t3 \$265 16.7641747213
* device instance _265_t4 r0 *1 0,0
R_265_t4 \$265__t4 \$265 9.52844849363
* device instance _265 r0 *1 0,0
C_265 \$265 vsubs 7.83841e-16
* device instance _268_t0 r0 *1 0,0
R_268_t0 \$268__t0 \$268 17.162141452
* device instance _268_t1 r0 *1 0,0
R_268_t1 \$268__t1 \$268 14.0706287935
* device instance _268_t2 r0 *1 0,0
R_268_t2 \$268__t2 \$268 13.6875065396
* device instance _268_t3 r0 *1 0,0
R_268_t3 \$268__t3 \$268 16.7641747213
* device instance _268_t4 r0 *1 0,0
R_268_t4 \$268__t4 \$268 9.52844849363
* device instance _268 r0 *1 0,0
C_268 \$268 vsubs 7.83841e-16
* device instance _27_t0 r0 *1 0,0
R_27_t0 \$27__t0 \$27 14.0706287935
* device instance _27_t1 r0 *1 0,0
R_27_t1 \$27__t1 \$27 17.162141452
* device instance _27_t2 r0 *1 0,0
R_27_t2 \$27__t2 \$27 13.6875065396
* device instance _27_t3 r0 *1 0,0
R_27_t3 \$27__t3 \$27 9.52844849363
* device instance _27_t4 r0 *1 0,0
R_27_t4 \$27__t4 \$27 16.7641747213
* device instance _27 r0 *1 0,0
C_27 \$27 vsubs 7.92193e-16
* device instance _271_t0 r0 *1 0,0
R_271_t0 \$271__t0 \$271 17.162141452
* device instance _271_t1 r0 *1 0,0
R_271_t1 \$271__t1 \$271 14.0706287935
* device instance _271_t2 r0 *1 0,0
R_271_t2 \$271__t2 \$271 13.6875065396
* device instance _271_t3 r0 *1 0,0
R_271_t3 \$271__t3 \$271 16.7641747213
* device instance _271_t4 r0 *1 0,0
R_271_t4 \$271__t4 \$271 9.52844849363
* device instance _271 r0 *1 0,0
C_271 \$271 vsubs 7.83841e-16
* device instance _274_t0 r0 *1 0,0
R_274_t0 \$274__t0 \$274 17.162141452
* device instance _274_t1 r0 *1 0,0
R_274_t1 \$274__t1 \$274 14.0706287935
* device instance _274_t2 r0 *1 0,0
R_274_t2 \$274__t2 \$274 13.6875065396
* device instance _274_t3 r0 *1 0,0
R_274_t3 \$274__t3 \$274 16.7641747213
* device instance _274_t4 r0 *1 0,0
R_274_t4 \$274__t4 \$274 9.52844849363
* device instance _274 r0 *1 0,0
C_274 \$274 vsubs 7.83841e-16
* device instance _277_t0 r0 *1 0,0
R_277_t0 \$277__t0 \$277 17.162141452
* device instance _277_t1 r0 *1 0,0
R_277_t1 \$277__t1 \$277 14.0706287935
* device instance _277_t2 r0 *1 0,0
R_277_t2 \$277__t2 \$277 13.6875065396
* device instance _277_t3 r0 *1 0,0
R_277_t3 \$277__t3 \$277 16.7641747213
* device instance _277_t4 r0 *1 0,0
R_277_t4 \$277__t4 \$277 9.52844849363
* device instance _277 r0 *1 0,0
C_277 \$277 vsubs 7.83841e-16
* device instance _28_t0 r0 *1 0,0
R_28_t0 \$28__t0 \$28 14.0706287935
* device instance _28_t1 r0 *1 0,0
R_28_t1 \$28__t1 \$28 17.162141452
* device instance _28_t2 r0 *1 0,0
R_28_t2 \$28__t2 \$28 13.6875065396
* device instance _28_t3 r0 *1 0,0
R_28_t3 \$28__t3 \$28 9.52844849363
* device instance _28_t4 r0 *1 0,0
R_28_t4 \$28__t4 \$28 16.7641747213
* device instance _28 r0 *1 0,0
C_28 \$28 vsubs 7.92193e-16
* device instance _280_t0 r0 *1 0,0
R_280_t0 \$280__t0 \$280 17.162141452
* device instance _280_t1 r0 *1 0,0
R_280_t1 \$280__t1 \$280 14.0706287935
* device instance _280_t2 r0 *1 0,0
R_280_t2 \$280__t2 \$280 13.6875065396
* device instance _280_t3 r0 *1 0,0
R_280_t3 \$280__t3 \$280 16.7641747213
* device instance _280_t4 r0 *1 0,0
R_280_t4 \$280__t4 \$280 9.52844849363
* device instance _280 r0 *1 0,0
C_280 \$280 vsubs 7.83841e-16
* device instance _283_t0 r0 *1 0,0
R_283_t0 \$283__t0 \$283 17.162141452
* device instance _283_t1 r0 *1 0,0
R_283_t1 \$283__t1 \$283 14.0706287935
* device instance _283_t2 r0 *1 0,0
R_283_t2 \$283__t2 \$283 13.6875065396
* device instance _283_t3 r0 *1 0,0
R_283_t3 \$283__t3 \$283 16.7641747213
* device instance _283_t4 r0 *1 0,0
R_283_t4 \$283__t4 \$283 9.52844849363
* device instance _283 r0 *1 0,0
C_283 \$283 vsubs 7.83841e-16
* device instance _286_t0 r0 *1 0,0
R_286_t0 \$286__t0 \$286 17.162141452
* device instance _286_t1 r0 *1 0,0
R_286_t1 \$286__t1 \$286 14.0706287935
* device instance _286_t2 r0 *1 0,0
R_286_t2 \$286__t2 \$286 13.6875065396
* device instance _286_t3 r0 *1 0,0
R_286_t3 \$286__t3 \$286 16.7641747213
* device instance _286_t4 r0 *1 0,0
R_286_t4 \$286__t4 \$286 9.52844849363
* device instance _286 r0 *1 0,0
C_286 \$286 vsubs 7.83841e-16
* device instance _289_t0 r0 *1 0,0
R_289_t0 \$289__t0 \$289 17.162141452
* device instance _289_t1 r0 *1 0,0
R_289_t1 \$289__t1 \$289 14.0706287935
* device instance _289_t2 r0 *1 0,0
R_289_t2 \$289__t2 \$289 13.6875065396
* device instance _289_t3 r0 *1 0,0
R_289_t3 \$289__t3 \$289 16.7641747213
* device instance _289_t4 r0 *1 0,0
R_289_t4 \$289__t4 \$289 9.52844849363
* device instance _289 r0 *1 0,0
C_289 \$289 vsubs 7.83841e-16
* device instance _29_t0 r0 *1 0,0
R_29_t0 \$29__t0 \$29 14.0706287935
* device instance _29_t1 r0 *1 0,0
R_29_t1 \$29__t1 \$29 17.162141452
* device instance _29_t2 r0 *1 0,0
R_29_t2 \$29__t2 \$29 13.6875065396
* device instance _29_t3 r0 *1 0,0
R_29_t3 \$29__t3 \$29 9.52844849363
* device instance _29_t4 r0 *1 0,0
R_29_t4 \$29__t4 \$29 16.7641747213
* device instance _29 r0 *1 0,0
C_29 \$29 vsubs 7.92193e-16
* device instance _292_t0 r0 *1 0,0
R_292_t0 \$292__t0 \$292 17.162141452
* device instance _292_t1 r0 *1 0,0
R_292_t1 \$292__t1 \$292 14.0706287935
* device instance _292_t2 r0 *1 0,0
R_292_t2 \$292__t2 \$292 13.6875065396
* device instance _292_t3 r0 *1 0,0
R_292_t3 \$292__t3 \$292 16.7641747213
* device instance _292_t4 r0 *1 0,0
R_292_t4 \$292__t4 \$292 9.52844849363
* device instance _292 r0 *1 0,0
C_292 \$292 vsubs 7.83841e-16
* device instance _295_t0 r0 *1 0,0
R_295_t0 \$295__t0 \$295 17.162141452
* device instance _295_t1 r0 *1 0,0
R_295_t1 \$295__t1 \$295 14.0706287935
* device instance _295_t2 r0 *1 0,0
R_295_t2 \$295__t2 \$295 13.6875065396
* device instance _295_t3 r0 *1 0,0
R_295_t3 \$295__t3 \$295 16.7641747213
* device instance _295_t4 r0 *1 0,0
R_295_t4 \$295__t4 \$295 9.52844849363
* device instance _295 r0 *1 0,0
C_295 \$295 vsubs 7.83841e-16
* device instance _298_t0 r0 *1 0,0
R_298_t0 \$298__t0 \$298 17.162141452
* device instance _298_t1 r0 *1 0,0
R_298_t1 \$298__t1 \$298 14.0706287935
* device instance _298_t2 r0 *1 0,0
R_298_t2 \$298__t2 \$298 13.6875065396
* device instance _298_t3 r0 *1 0,0
R_298_t3 \$298__t3 \$298 16.7641747213
* device instance _298_t4 r0 *1 0,0
R_298_t4 \$298__t4 \$298 9.52844849363
* device instance _298 r0 *1 0,0
C_298 \$298 vsubs 7.83841e-16
* device instance _30_t0 r0 *1 0,0
R_30_t0 \$30__t0 \$30 14.0706287935
* device instance _30_t1 r0 *1 0,0
R_30_t1 \$30__t1 \$30 17.162141452
* device instance _30_t2 r0 *1 0,0
R_30_t2 \$30__t2 \$30 13.6875065396
* device instance _30_t3 r0 *1 0,0
R_30_t3 \$30__t3 \$30 9.52844849363
* device instance _30_t4 r0 *1 0,0
R_30_t4 \$30__t4 \$30 16.7641747213
* device instance _30 r0 *1 0,0
C_30 \$30 vsubs 7.92193e-16
* device instance _301_t0 r0 *1 0,0
R_301_t0 \$301__t0 \$301 17.162141452
* device instance _301_t1 r0 *1 0,0
R_301_t1 \$301__t1 \$301 14.0706287935
* device instance _301_t2 r0 *1 0,0
R_301_t2 \$301__t2 \$301 13.6875065396
* device instance _301_t3 r0 *1 0,0
R_301_t3 \$301__t3 \$301 16.7641747213
* device instance _301_t4 r0 *1 0,0
R_301_t4 \$301__t4 \$301 9.52844849363
* device instance _301 r0 *1 0,0
C_301 \$301 vsubs 7.83841e-16
* device instance _304_t0 r0 *1 0,0
R_304_t0 \$304__t0 \$304 17.162141452
* device instance _304_t1 r0 *1 0,0
R_304_t1 \$304__t1 \$304 14.0706287935
* device instance _304_t2 r0 *1 0,0
R_304_t2 \$304__t2 \$304 13.6875065396
* device instance _304_t3 r0 *1 0,0
R_304_t3 \$304__t3 \$304 16.7641747213
* device instance _304_t4 r0 *1 0,0
R_304_t4 \$304__t4 \$304 9.52844849363
* device instance _304 r0 *1 0,0
C_304 \$304 vsubs 7.83841e-16
* device instance _307_t0 r0 *1 0,0
R_307_t0 \$307__t0 \$307 17.162141452
* device instance _307_t1 r0 *1 0,0
R_307_t1 \$307__t1 \$307 14.0706287935
* device instance _307_t2 r0 *1 0,0
R_307_t2 \$307__t2 \$307 13.6875065396
* device instance _307_t3 r0 *1 0,0
R_307_t3 \$307__t3 \$307 16.7641747213
* device instance _307_t4 r0 *1 0,0
R_307_t4 \$307__t4 \$307 9.52844849363
* device instance _307 r0 *1 0,0
C_307 \$307 vsubs 7.83841e-16
* device instance _31_t0 r0 *1 0,0
R_31_t0 \$31__t0 \$31 14.0706287935
* device instance _31_t1 r0 *1 0,0
R_31_t1 \$31__t1 \$31 17.162141452
* device instance _31_t2 r0 *1 0,0
R_31_t2 \$31__t2 \$31 13.6875065396
* device instance _31_t3 r0 *1 0,0
R_31_t3 \$31__t3 \$31 9.52844849363
* device instance _31_t4 r0 *1 0,0
R_31_t4 \$31__t4 \$31 16.7641747213
* device instance _31 r0 *1 0,0
C_31 \$31 vsubs 7.92193e-16
* device instance _310_t0 r0 *1 0,0
R_310_t0 \$310__t0 \$310 17.162141452
* device instance _310_t1 r0 *1 0,0
R_310_t1 \$310__t1 \$310 14.0706287935
* device instance _310_t2 r0 *1 0,0
R_310_t2 \$310__t2 \$310 13.6875065396
* device instance _310_t3 r0 *1 0,0
R_310_t3 \$310__t3 \$310 16.7641747213
* device instance _310_t4 r0 *1 0,0
R_310_t4 \$310__t4 \$310 9.52844849363
* device instance _310 r0 *1 0,0
C_310 \$310 vsubs 7.83841e-16
* device instance _313_t0 r0 *1 0,0
R_313_t0 \$313__t0 \$313 17.162141452
* device instance _313_t1 r0 *1 0,0
R_313_t1 \$313__t1 \$313 14.0706287935
* device instance _313_t2 r0 *1 0,0
R_313_t2 \$313__t2 \$313 13.6875065396
* device instance _313_t3 r0 *1 0,0
R_313_t3 \$313__t3 \$313 16.7641747213
* device instance _313_t4 r0 *1 0,0
R_313_t4 \$313__t4 \$313 9.52844849363
* device instance _313 r0 *1 0,0
C_313 \$313 vsubs 7.83841e-16
* device instance _316_t0 r0 *1 0,0
R_316_t0 \$316__t0 \$316 17.162141452
* device instance _316_t1 r0 *1 0,0
R_316_t1 \$316__t1 \$316 14.0706287935
* device instance _316_t2 r0 *1 0,0
R_316_t2 \$316__t2 \$316 13.6875065396
* device instance _316_t3 r0 *1 0,0
R_316_t3 \$316__t3 \$316 16.7641747213
* device instance _316_t4 r0 *1 0,0
R_316_t4 \$316__t4 \$316 9.52844849363
* device instance _316 r0 *1 0,0
C_316 \$316 vsubs 7.83841e-16
* device instance _319_t0 r0 *1 0,0
R_319_t0 \$319__t0 \$319 17.162141452
* device instance _319_t1 r0 *1 0,0
R_319_t1 \$319__t1 \$319 14.0706287935
* device instance _319_t2 r0 *1 0,0
R_319_t2 \$319__t2 \$319 13.6875065396
* device instance _319_t3 r0 *1 0,0
R_319_t3 \$319__t3 \$319 16.7641747213
* device instance _319_t4 r0 *1 0,0
R_319_t4 \$319__t4 \$319 9.52844849363
* device instance _319 r0 *1 0,0
C_319 \$319 vsubs 7.83841e-16
* device instance _32_t0 r0 *1 0,0
R_32_t0 \$32__t0 \$32 14.0706287935
* device instance _32_t1 r0 *1 0,0
R_32_t1 \$32__t1 \$32 17.162141452
* device instance _32_t2 r0 *1 0,0
R_32_t2 \$32__t2 \$32 13.6875065396
* device instance _32_t3 r0 *1 0,0
R_32_t3 \$32__t3 \$32 9.52844849363
* device instance _32_t4 r0 *1 0,0
R_32_t4 \$32__t4 \$32 16.7641747213
* device instance _32 r0 *1 0,0
C_32 \$32 vsubs 7.92193e-16
* device instance _322_t0 r0 *1 0,0
R_322_t0 \$322__t0 \$322 17.162141452
* device instance _322_t1 r0 *1 0,0
R_322_t1 \$322__t1 \$322 14.0706287935
* device instance _322_t2 r0 *1 0,0
R_322_t2 \$322__t2 \$322 13.6875065396
* device instance _322_t3 r0 *1 0,0
R_322_t3 \$322__t3 \$322 16.7641747213
* device instance _322_t4 r0 *1 0,0
R_322_t4 \$322__t4 \$322 9.52844849363
* device instance _322 r0 *1 0,0
C_322 \$322 vsubs 7.83841e-16
* device instance _325_t0 r0 *1 0,0
R_325_t0 \$325__t0 \$325 17.162141452
* device instance _325_t1 r0 *1 0,0
R_325_t1 \$325__t1 \$325 14.0706287935
* device instance _325_t2 r0 *1 0,0
R_325_t2 \$325__t2 \$325 13.6875065396
* device instance _325_t3 r0 *1 0,0
R_325_t3 \$325__t3 \$325 16.7641747213
* device instance _325_t4 r0 *1 0,0
R_325_t4 \$325__t4 \$325 9.52844849363
* device instance _325 r0 *1 0,0
C_325 \$325 vsubs 7.83841e-16
* device instance _328_t0 r0 *1 0,0
R_328_t0 \$328__t0 \$328 17.162141452
* device instance _328_t1 r0 *1 0,0
R_328_t1 \$328__t1 \$328 14.0706287935
* device instance _328_t2 r0 *1 0,0
R_328_t2 \$328__t2 \$328 13.6875065396
* device instance _328_t3 r0 *1 0,0
R_328_t3 \$328__t3 \$328 16.7641747213
* device instance _328_t4 r0 *1 0,0
R_328_t4 \$328__t4 \$328 9.52844849363
* device instance _328 r0 *1 0,0
C_328 \$328 vsubs 7.83841e-16
* device instance _33_t0 r0 *1 0,0
R_33_t0 \$33__t0 \$33 14.0706287935
* device instance _33_t1 r0 *1 0,0
R_33_t1 \$33__t1 \$33 17.162141452
* device instance _33_t2 r0 *1 0,0
R_33_t2 \$33__t2 \$33 13.6875065396
* device instance _33_t3 r0 *1 0,0
R_33_t3 \$33__t3 \$33 9.52844849363
* device instance _33_t4 r0 *1 0,0
R_33_t4 \$33__t4 \$33 16.7641747213
* device instance _33 r0 *1 0,0
C_33 \$33 vsubs 7.92193e-16
* device instance _331_t0 r0 *1 0,0
R_331_t0 \$331__t0 \$331 17.162141452
* device instance _331_t1 r0 *1 0,0
R_331_t1 \$331__t1 \$331 14.0706287935
* device instance _331_t2 r0 *1 0,0
R_331_t2 \$331__t2 \$331 13.6875065396
* device instance _331_t3 r0 *1 0,0
R_331_t3 \$331__t3 \$331 16.7641747213
* device instance _331_t4 r0 *1 0,0
R_331_t4 \$331__t4 \$331 9.52844849363
* device instance _331 r0 *1 0,0
C_331 \$331 vsubs 7.83841e-16
* device instance _334_t0 r0 *1 0,0
R_334_t0 \$334__t0 \$334 17.162141452
* device instance _334_t1 r0 *1 0,0
R_334_t1 \$334__t1 \$334 14.0706287935
* device instance _334_t2 r0 *1 0,0
R_334_t2 \$334__t2 \$334 13.6875065396
* device instance _334_t3 r0 *1 0,0
R_334_t3 \$334__t3 \$334 16.7641747213
* device instance _334_t4 r0 *1 0,0
R_334_t4 \$334__t4 \$334 9.52844849363
* device instance _334 r0 *1 0,0
C_334 \$334 vsubs 7.83841e-16
* device instance _337_t0 r0 *1 0,0
R_337_t0 \$337__t0 \$337 17.162141452
* device instance _337_t1 r0 *1 0,0
R_337_t1 \$337__t1 \$337 14.0706287935
* device instance _337_t2 r0 *1 0,0
R_337_t2 \$337__t2 \$337 13.6875065396
* device instance _337_t3 r0 *1 0,0
R_337_t3 \$337__t3 \$337 16.7641747213
* device instance _337_t4 r0 *1 0,0
R_337_t4 \$337__t4 \$337 9.52844849363
* device instance _337 r0 *1 0,0
C_337 \$337 vsubs 7.83841e-16
* device instance _34_t0 r0 *1 0,0
R_34_t0 \$34__t0 \$34 14.0706287935
* device instance _34_t1 r0 *1 0,0
R_34_t1 \$34__t1 \$34 17.162141452
* device instance _34_t2 r0 *1 0,0
R_34_t2 \$34__t2 \$34 13.6875065396
* device instance _34_t3 r0 *1 0,0
R_34_t3 \$34__t3 \$34 9.52844849363
* device instance _34_t4 r0 *1 0,0
R_34_t4 \$34__t4 \$34 16.7641747213
* device instance _34 r0 *1 0,0
C_34 \$34 vsubs 7.92193e-16
* device instance _340_t0 r0 *1 0,0
R_340_t0 \$340__t0 \$340 17.162141452
* device instance _340_t1 r0 *1 0,0
R_340_t1 \$340__t1 \$340 14.0706287935
* device instance _340_t2 r0 *1 0,0
R_340_t2 \$340__t2 \$340 13.6875065396
* device instance _340_t3 r0 *1 0,0
R_340_t3 \$340__t3 \$340 16.7641747213
* device instance _340_t4 r0 *1 0,0
R_340_t4 \$340__t4 \$340 9.52844849363
* device instance _340 r0 *1 0,0
C_340 \$340 vsubs 7.83841e-16
* device instance _343_t0 r0 *1 0,0
R_343_t0 \$343__t0 \$343 17.162141452
* device instance _343_t1 r0 *1 0,0
R_343_t1 \$343__t1 \$343 14.0706287935
* device instance _343_t2 r0 *1 0,0
R_343_t2 \$343__t2 \$343 13.6875065396
* device instance _343_t3 r0 *1 0,0
R_343_t3 \$343__t3 \$343 16.7641747213
* device instance _343_t4 r0 *1 0,0
R_343_t4 \$343__t4 \$343 9.52844849363
* device instance _343 r0 *1 0,0
C_343 \$343 vsubs 7.83841e-16
* device instance _346_t0 r0 *1 0,0
R_346_t0 \$346__t0 \$346 17.162141452
* device instance _346_t1 r0 *1 0,0
R_346_t1 \$346__t1 \$346 14.0706287935
* device instance _346_t2 r0 *1 0,0
R_346_t2 \$346__t2 \$346 13.6875065396
* device instance _346_t3 r0 *1 0,0
R_346_t3 \$346__t3 \$346 16.7641747213
* device instance _346_t4 r0 *1 0,0
R_346_t4 \$346__t4 \$346 9.52844849363
* device instance _346 r0 *1 0,0
C_346 \$346 vsubs 7.83841e-16
* device instance _349_t0 r0 *1 0,0
R_349_t0 \$349__t0 \$349 17.162141452
* device instance _349_t1 r0 *1 0,0
R_349_t1 \$349__t1 \$349 14.0706287935
* device instance _349_t2 r0 *1 0,0
R_349_t2 \$349__t2 \$349 13.6875065396
* device instance _349_t3 r0 *1 0,0
R_349_t3 \$349__t3 \$349 16.7641747213
* device instance _349_t4 r0 *1 0,0
R_349_t4 \$349__t4 \$349 9.52844849363
* device instance _349 r0 *1 0,0
C_349 \$349 vsubs 7.83841e-16
* device instance _35_t0 r0 *1 0,0
R_35_t0 \$35__t0 \$35 14.0706287935
* device instance _35_t1 r0 *1 0,0
R_35_t1 \$35__t1 \$35 17.162141452
* device instance _35_t2 r0 *1 0,0
R_35_t2 \$35__t2 \$35 13.6875065396
* device instance _35_t3 r0 *1 0,0
R_35_t3 \$35__t3 \$35 9.52844849363
* device instance _35_t4 r0 *1 0,0
R_35_t4 \$35__t4 \$35 16.7641747213
* device instance _35 r0 *1 0,0
C_35 \$35 vsubs 7.92193e-16
* device instance _352_t0 r0 *1 0,0
R_352_t0 \$352__t0 \$352 17.162141452
* device instance _352_t1 r0 *1 0,0
R_352_t1 \$352__t1 \$352 14.0706287935
* device instance _352_t2 r0 *1 0,0
R_352_t2 \$352__t2 \$352 13.6875065396
* device instance _352_t3 r0 *1 0,0
R_352_t3 \$352__t3 \$352 16.7641747213
* device instance _352_t4 r0 *1 0,0
R_352_t4 \$352__t4 \$352 9.52844849363
* device instance _352 r0 *1 0,0
C_352 \$352 vsubs 7.83841e-16
* device instance _355_t0 r0 *1 0,0
R_355_t0 \$355__t0 \$355 17.162141452
* device instance _355_t1 r0 *1 0,0
R_355_t1 \$355__t1 \$355 14.0706287935
* device instance _355_t2 r0 *1 0,0
R_355_t2 \$355__t2 \$355 13.6875065396
* device instance _355_t3 r0 *1 0,0
R_355_t3 \$355__t3 \$355 16.7641747213
* device instance _355_t4 r0 *1 0,0
R_355_t4 \$355__t4 \$355 9.52844849363
* device instance _355 r0 *1 0,0
C_355 \$355 vsubs 7.83841e-16
* device instance _358_t0 r0 *1 0,0
R_358_t0 \$358__t0 \$358 17.162141452
* device instance _358_t1 r0 *1 0,0
R_358_t1 \$358__t1 \$358 14.0706287935
* device instance _358_t2 r0 *1 0,0
R_358_t2 \$358__t2 \$358 13.6875065396
* device instance _358_t3 r0 *1 0,0
R_358_t3 \$358__t3 \$358 16.7641747213
* device instance _358_t4 r0 *1 0,0
R_358_t4 \$358__t4 \$358 9.52844849363
* device instance _358 r0 *1 0,0
C_358 \$358 vsubs 7.83841e-16
* device instance _36_t0 r0 *1 0,0
R_36_t0 \$36__t0 \$36 14.0706287935
* device instance _36_t1 r0 *1 0,0
R_36_t1 \$36__t1 \$36 17.162141452
* device instance _36_t2 r0 *1 0,0
R_36_t2 \$36__t2 \$36 13.6875065396
* device instance _36_t3 r0 *1 0,0
R_36_t3 \$36__t3 \$36 9.52844849363
* device instance _36_t4 r0 *1 0,0
R_36_t4 \$36__t4 \$36 16.7641747213
* device instance _36 r0 *1 0,0
C_36 \$36 vsubs 7.92193e-16
* device instance _361_t0 r0 *1 0,0
R_361_t0 \$361__t0 \$361 17.162141452
* device instance _361_t1 r0 *1 0,0
R_361_t1 \$361__t1 \$361 14.0706287935
* device instance _361_t2 r0 *1 0,0
R_361_t2 \$361__t2 \$361 13.6875065396
* device instance _361_t3 r0 *1 0,0
R_361_t3 \$361__t3 \$361 16.7641747213
* device instance _361_t4 r0 *1 0,0
R_361_t4 \$361__t4 \$361 9.52844849363
* device instance _361 r0 *1 0,0
C_361 \$361 vsubs 7.83841e-16
* device instance _364_t0 r0 *1 0,0
R_364_t0 \$364__t0 \$364 17.162141452
* device instance _364_t1 r0 *1 0,0
R_364_t1 \$364__t1 \$364 14.0706287935
* device instance _364_t2 r0 *1 0,0
R_364_t2 \$364__t2 \$364 13.6875065396
* device instance _364_t3 r0 *1 0,0
R_364_t3 \$364__t3 \$364 16.7641747213
* device instance _364_t4 r0 *1 0,0
R_364_t4 \$364__t4 \$364 9.52844849363
* device instance _364 r0 *1 0,0
C_364 \$364 vsubs 7.83841e-16
* device instance _367_t0 r0 *1 0,0
R_367_t0 \$367__t0 \$367 17.162141452
* device instance _367_t1 r0 *1 0,0
R_367_t1 \$367__t1 \$367 14.0706287935
* device instance _367_t2 r0 *1 0,0
R_367_t2 \$367__t2 \$367 13.6875065396
* device instance _367_t3 r0 *1 0,0
R_367_t3 \$367__t3 \$367 16.7641747213
* device instance _367_t4 r0 *1 0,0
R_367_t4 \$367__t4 \$367 9.52844849363
* device instance _367 r0 *1 0,0
C_367 \$367 vsubs 7.83841e-16
* device instance _37_t0 r0 *1 0,0
R_37_t0 \$37__t0 \$37 14.0706287935
* device instance _37_t1 r0 *1 0,0
R_37_t1 \$37__t1 \$37 17.162141452
* device instance _37_t2 r0 *1 0,0
R_37_t2 \$37__t2 \$37 13.6875065396
* device instance _37_t3 r0 *1 0,0
R_37_t3 \$37__t3 \$37 9.52844849363
* device instance _37_t4 r0 *1 0,0
R_37_t4 \$37__t4 \$37 16.7641747213
* device instance _37 r0 *1 0,0
C_37 \$37 vsubs 7.92193e-16
* device instance _370_t0 r0 *1 0,0
R_370_t0 \$370__t0 \$370 17.162141452
* device instance _370_t1 r0 *1 0,0
R_370_t1 \$370__t1 \$370 14.0706287935
* device instance _370_t2 r0 *1 0,0
R_370_t2 \$370__t2 \$370 13.6875065396
* device instance _370_t3 r0 *1 0,0
R_370_t3 \$370__t3 \$370 16.7641747213
* device instance _370_t4 r0 *1 0,0
R_370_t4 \$370__t4 \$370 9.52844849363
* device instance _370 r0 *1 0,0
C_370 \$370 vsubs 7.83841e-16
* device instance _373_t0 r0 *1 0,0
R_373_t0 \$373__t0 \$373 17.162141452
* device instance _373_t1 r0 *1 0,0
R_373_t1 \$373__t1 \$373 14.0706287935
* device instance _373_t2 r0 *1 0,0
R_373_t2 \$373__t2 \$373 13.6875065396
* device instance _373_t3 r0 *1 0,0
R_373_t3 \$373__t3 \$373 16.7641747213
* device instance _373_t4 r0 *1 0,0
R_373_t4 \$373__t4 \$373 9.52844849363
* device instance _373 r0 *1 0,0
C_373 \$373 vsubs 7.83841e-16
* device instance _376_t0 r0 *1 0,0
R_376_t0 \$376__t0 \$376 17.162141452
* device instance _376_t1 r0 *1 0,0
R_376_t1 \$376__t1 \$376 14.0706287935
* device instance _376_t2 r0 *1 0,0
R_376_t2 \$376__t2 \$376 13.6875065396
* device instance _376_t3 r0 *1 0,0
R_376_t3 \$376__t3 \$376 16.7641747213
* device instance _376_t4 r0 *1 0,0
R_376_t4 \$376__t4 \$376 9.52844849363
* device instance _376 r0 *1 0,0
C_376 \$376 vsubs 7.83841e-16
* device instance _379_t0 r0 *1 0,0
R_379_t0 \$379__t0 \$379 17.162141452
* device instance _379_t1 r0 *1 0,0
R_379_t1 \$379__t1 \$379 14.0706287935
* device instance _379_t2 r0 *1 0,0
R_379_t2 \$379__t2 \$379 13.6875065396
* device instance _379_t3 r0 *1 0,0
R_379_t3 \$379__t3 \$379 16.7641747213
* device instance _379_t4 r0 *1 0,0
R_379_t4 \$379__t4 \$379 9.52844849363
* device instance _379 r0 *1 0,0
C_379 \$379 vsubs 7.83841e-16
* device instance _38_t0 r0 *1 0,0
R_38_t0 \$38__t0 \$38 14.0706287935
* device instance _38_t1 r0 *1 0,0
R_38_t1 \$38__t1 \$38 17.162141452
* device instance _38_t2 r0 *1 0,0
R_38_t2 \$38__t2 \$38 13.6875065396
* device instance _38_t3 r0 *1 0,0
R_38_t3 \$38__t3 \$38 9.52844849363
* device instance _38_t4 r0 *1 0,0
R_38_t4 \$38__t4 \$38 16.7641747213
* device instance _38 r0 *1 0,0
C_38 \$38 vsubs 7.92193e-16
* device instance _382_t0 r0 *1 0,0
R_382_t0 \$382__t0 \$382 17.162141452
* device instance _382_t1 r0 *1 0,0
R_382_t1 \$382__t1 \$382 14.0706287935
* device instance _382_t2 r0 *1 0,0
R_382_t2 \$382__t2 \$382 13.6875065396
* device instance _382_t3 r0 *1 0,0
R_382_t3 \$382__t3 \$382 16.7641747213
* device instance _382_t4 r0 *1 0,0
R_382_t4 \$382__t4 \$382 9.52844849363
* device instance _382 r0 *1 0,0
C_382 \$382 vsubs 7.83841e-16
* device instance _385_t0 r0 *1 0,0
R_385_t0 \$385__t0 \$385 17.162141452
* device instance _385_t1 r0 *1 0,0
R_385_t1 \$385__t1 \$385 14.0706287935
* device instance _385_t2 r0 *1 0,0
R_385_t2 \$385__t2 \$385 13.6875065396
* device instance _385_t3 r0 *1 0,0
R_385_t3 \$385__t3 \$385 16.7641747213
* device instance _385_t4 r0 *1 0,0
R_385_t4 \$385__t4 \$385 9.52844849363
* device instance _385 r0 *1 0,0
C_385 \$385 vsubs 7.83841e-16
* device instance _388_t0 r0 *1 0,0
R_388_t0 \$388__t0 \$388 17.162141452
* device instance _388_t1 r0 *1 0,0
R_388_t1 \$388__t1 \$388 14.0706287935
* device instance _388_t2 r0 *1 0,0
R_388_t2 \$388__t2 \$388 13.6875065396
* device instance _388_t3 r0 *1 0,0
R_388_t3 \$388__t3 \$388 16.7641747213
* device instance _388_t4 r0 *1 0,0
R_388_t4 \$388__t4 \$388 9.52844849363
* device instance _388 r0 *1 0,0
C_388 \$388 vsubs 7.83841e-16
* device instance _39_t0 r0 *1 0,0
R_39_t0 \$39__t0 \$39 14.0706287935
* device instance _39_t1 r0 *1 0,0
R_39_t1 \$39__t1 \$39 17.162141452
* device instance _39_t2 r0 *1 0,0
R_39_t2 \$39__t2 \$39 13.6875065396
* device instance _39_t3 r0 *1 0,0
R_39_t3 \$39__t3 \$39 9.52844849363
* device instance _39_t4 r0 *1 0,0
R_39_t4 \$39__t4 \$39 16.7641747213
* device instance _39 r0 *1 0,0
C_39 \$39 vsubs 7.92193e-16
* device instance _391_t0 r0 *1 0,0
R_391_t0 \$391__t0 \$391 17.162141452
* device instance _391_t1 r0 *1 0,0
R_391_t1 \$391__t1 \$391 14.0706287935
* device instance _391_t2 r0 *1 0,0
R_391_t2 \$391__t2 \$391 13.6875065396
* device instance _391_t3 r0 *1 0,0
R_391_t3 \$391__t3 \$391 16.7641747213
* device instance _391_t4 r0 *1 0,0
R_391_t4 \$391__t4 \$391 9.52844849363
* device instance _391 r0 *1 0,0
C_391 \$391 vsubs 7.83841e-16
* device instance _394_t0 r0 *1 0,0
R_394_t0 \$394__t0 \$394 17.162141452
* device instance _394_t1 r0 *1 0,0
R_394_t1 \$394__t1 \$394 14.0706287935
* device instance _394_t2 r0 *1 0,0
R_394_t2 \$394__t2 \$394 13.6875065396
* device instance _394_t3 r0 *1 0,0
R_394_t3 \$394__t3 \$394 16.7641747213
* device instance _394_t4 r0 *1 0,0
R_394_t4 \$394__t4 \$394 9.52844849363
* device instance _394 r0 *1 0,0
C_394 \$394 vsubs 7.83841e-16
* device instance _397_t0 r0 *1 0,0
R_397_t0 \$397__t0 \$397 17.162141452
* device instance _397_t1 r0 *1 0,0
R_397_t1 \$397__t1 \$397 14.0706287935
* device instance _397_t2 r0 *1 0,0
R_397_t2 \$397__t2 \$397 13.6875065396
* device instance _397_t3 r0 *1 0,0
R_397_t3 \$397__t3 \$397 16.7641747213
* device instance _397_t4 r0 *1 0,0
R_397_t4 \$397__t4 \$397 9.52844849363
* device instance _397 r0 *1 0,0
C_397 \$397 vsubs 7.83841e-16
* device instance _4_t0 r0 *1 0,0
R_4_t0 \$4__t0 \$4 13.6875065396
* device instance _4_t1 r0 *1 0,0
R_4_t1 \$4__t1 \$4 17.162141452
* device instance _4_t2 r0 *1 0,0
R_4_t2 \$4__t2 \$4 14.0706287935
* device instance _4_t3 r0 *1 0,0
R_4_t3 \$4__t3 \$4 16.7641747213
* device instance _4_t4 r0 *1 0,0
R_4_t4 \$4__t4 \$4 9.52844849363
* device instance _4 r0 *1 0,0
C_4 \$4 vsubs 7.92193e-16
* device instance _40_t0 r0 *1 0,0
R_40_t0 \$40__t0 \$40 14.0706287935
* device instance _40_t1 r0 *1 0,0
R_40_t1 \$40__t1 \$40 17.162141452
* device instance _40_t2 r0 *1 0,0
R_40_t2 \$40__t2 \$40 13.6875065396
* device instance _40_t3 r0 *1 0,0
R_40_t3 \$40__t3 \$40 9.52844849363
* device instance _40_t4 r0 *1 0,0
R_40_t4 \$40__t4 \$40 16.7641747213
* device instance _40 r0 *1 0,0
C_40 \$40 vsubs 7.92193e-16
* device instance _400_t0 r0 *1 0,0
R_400_t0 \$400__t0 \$400 17.162141452
* device instance _400_t1 r0 *1 0,0
R_400_t1 \$400__t1 \$400 14.0706287935
* device instance _400_t2 r0 *1 0,0
R_400_t2 \$400__t2 \$400 13.6875065396
* device instance _400_t3 r0 *1 0,0
R_400_t3 \$400__t3 \$400 16.7641747213
* device instance _400_t4 r0 *1 0,0
R_400_t4 \$400__t4 \$400 9.52844849363
* device instance _400 r0 *1 0,0
C_400 \$400 vsubs 7.83841e-16
* device instance _403_t0 r0 *1 0,0
R_403_t0 \$403__t0 \$403 17.162141452
* device instance _403_t1 r0 *1 0,0
R_403_t1 \$403__t1 \$403 14.0706287935
* device instance _403_t2 r0 *1 0,0
R_403_t2 \$403__t2 \$403 13.6875065396
* device instance _403_t3 r0 *1 0,0
R_403_t3 \$403__t3 \$403 16.7641747213
* device instance _403_t4 r0 *1 0,0
R_403_t4 \$403__t4 \$403 9.52844849363
* device instance _403 r0 *1 0,0
C_403 \$403 vsubs 7.83841e-16
* device instance _406_t0 r0 *1 0,0
R_406_t0 \$406__t0 \$406 17.162141452
* device instance _406_t1 r0 *1 0,0
R_406_t1 \$406__t1 \$406 14.0706287935
* device instance _406_t2 r0 *1 0,0
R_406_t2 \$406__t2 \$406 13.6875065396
* device instance _406_t3 r0 *1 0,0
R_406_t3 \$406__t3 \$406 16.7641747213
* device instance _406_t4 r0 *1 0,0
R_406_t4 \$406__t4 \$406 9.52844849363
* device instance _406 r0 *1 0,0
C_406 \$406 vsubs 7.83841e-16
* device instance _409_t0 r0 *1 0,0
R_409_t0 \$409__t0 \$409 17.162141452
* device instance _409_t1 r0 *1 0,0
R_409_t1 \$409__t1 \$409 14.0706287935
* device instance _409_t2 r0 *1 0,0
R_409_t2 \$409__t2 \$409 13.6875065396
* device instance _409_t3 r0 *1 0,0
R_409_t3 \$409__t3 \$409 16.7641747213
* device instance _409_t4 r0 *1 0,0
R_409_t4 \$409__t4 \$409 9.52844849363
* device instance _409 r0 *1 0,0
C_409 \$409 vsubs 7.83841e-16
* device instance _41_t0 r0 *1 0,0
R_41_t0 \$41__t0 \$41 14.0706287935
* device instance _41_t1 r0 *1 0,0
R_41_t1 \$41__t1 \$41 17.162141452
* device instance _41_t2 r0 *1 0,0
R_41_t2 \$41__t2 \$41 13.6875065396
* device instance _41_t3 r0 *1 0,0
R_41_t3 \$41__t3 \$41 9.52844849363
* device instance _41_t4 r0 *1 0,0
R_41_t4 \$41__t4 \$41 16.7641747213
* device instance _41 r0 *1 0,0
C_41 \$41 vsubs 7.92193e-16
* device instance _412_t0 r0 *1 0,0
R_412_t0 \$412__t0 \$412 17.162141452
* device instance _412_t1 r0 *1 0,0
R_412_t1 \$412__t1 \$412 14.0706287935
* device instance _412_t2 r0 *1 0,0
R_412_t2 \$412__t2 \$412 13.6875065396
* device instance _412_t3 r0 *1 0,0
R_412_t3 \$412__t3 \$412 16.7641747213
* device instance _412_t4 r0 *1 0,0
R_412_t4 \$412__t4 \$412 9.52844849363
* device instance _412 r0 *1 0,0
C_412 \$412 vsubs 7.83841e-16
* device instance _415_t0 r0 *1 0,0
R_415_t0 \$415__t0 \$415 17.162141452
* device instance _415_t1 r0 *1 0,0
R_415_t1 \$415__t1 \$415 14.0706287935
* device instance _415_t2 r0 *1 0,0
R_415_t2 \$415__t2 \$415 13.6875065396
* device instance _415_t3 r0 *1 0,0
R_415_t3 \$415__t3 \$415 16.7641747213
* device instance _415_t4 r0 *1 0,0
R_415_t4 \$415__t4 \$415 9.52844849363
* device instance _415 r0 *1 0,0
C_415 \$415 vsubs 7.83841e-16
* device instance _418_t0 r0 *1 0,0
R_418_t0 \$418__t0 \$418 17.162141452
* device instance _418_t1 r0 *1 0,0
R_418_t1 \$418__t1 \$418 14.0706287935
* device instance _418_t2 r0 *1 0,0
R_418_t2 \$418__t2 \$418 13.6875065396
* device instance _418_t3 r0 *1 0,0
R_418_t3 \$418__t3 \$418 16.7641747213
* device instance _418_t4 r0 *1 0,0
R_418_t4 \$418__t4 \$418 9.52844849363
* device instance _418 r0 *1 0,0
C_418 \$418 vsubs 7.83841e-16
* device instance _42_t0 r0 *1 0,0
R_42_t0 \$42__t0 \$42 14.0706287935
* device instance _42_t1 r0 *1 0,0
R_42_t1 \$42__t1 \$42 17.162141452
* device instance _42_t2 r0 *1 0,0
R_42_t2 \$42__t2 \$42 13.6875065396
* device instance _42_t3 r0 *1 0,0
R_42_t3 \$42__t3 \$42 9.52844849363
* device instance _42_t4 r0 *1 0,0
R_42_t4 \$42__t4 \$42 16.7641747213
* device instance _42 r0 *1 0,0
C_42 \$42 vsubs 7.92193e-16
* device instance _421_t0 r0 *1 0,0
R_421_t0 \$421__t0 \$421 17.162141452
* device instance _421_t1 r0 *1 0,0
R_421_t1 \$421__t1 \$421 14.0706287935
* device instance _421_t2 r0 *1 0,0
R_421_t2 \$421__t2 \$421 13.6875065396
* device instance _421_t3 r0 *1 0,0
R_421_t3 \$421__t3 \$421 16.7641747213
* device instance _421_t4 r0 *1 0,0
R_421_t4 \$421__t4 \$421 9.52844849363
* device instance _421 r0 *1 0,0
C_421 \$421 vsubs 7.83841e-16
* device instance _424_t0 r0 *1 0,0
R_424_t0 \$424__t0 \$424 17.162141452
* device instance _424_t1 r0 *1 0,0
R_424_t1 \$424__t1 \$424 14.0706287935
* device instance _424_t2 r0 *1 0,0
R_424_t2 \$424__t2 \$424 13.6875065396
* device instance _424_t3 r0 *1 0,0
R_424_t3 \$424__t3 \$424 16.7641747213
* device instance _424_t4 r0 *1 0,0
R_424_t4 \$424__t4 \$424 9.52844849363
* device instance _424 r0 *1 0,0
C_424 \$424 vsubs 7.83841e-16
* device instance _427_t0 r0 *1 0,0
R_427_t0 \$427__t0 \$427 17.162141452
* device instance _427_t1 r0 *1 0,0
R_427_t1 \$427__t1 \$427 14.0706287935
* device instance _427_t2 r0 *1 0,0
R_427_t2 \$427__t2 \$427 13.6875065396
* device instance _427_t3 r0 *1 0,0
R_427_t3 \$427__t3 \$427 16.7641747213
* device instance _427_t4 r0 *1 0,0
R_427_t4 \$427__t4 \$427 9.52844849363
* device instance _427 r0 *1 0,0
C_427 \$427 vsubs 7.83841e-16
* device instance _43_t0 r0 *1 0,0
R_43_t0 \$43__t0 \$43 14.0706287935
* device instance _43_t1 r0 *1 0,0
R_43_t1 \$43__t1 \$43 17.162141452
* device instance _43_t2 r0 *1 0,0
R_43_t2 \$43__t2 \$43 13.6875065396
* device instance _43_t3 r0 *1 0,0
R_43_t3 \$43__t3 \$43 9.52844849363
* device instance _43_t4 r0 *1 0,0
R_43_t4 \$43__t4 \$43 16.7641747213
* device instance _43 r0 *1 0,0
C_43 \$43 vsubs 7.92193e-16
* device instance _430_t0 r0 *1 0,0
R_430_t0 \$430__t0 \$430 17.162141452
* device instance _430_t1 r0 *1 0,0
R_430_t1 \$430__t1 \$430 14.0706287935
* device instance _430_t2 r0 *1 0,0
R_430_t2 \$430__t2 \$430 13.6875065396
* device instance _430_t3 r0 *1 0,0
R_430_t3 \$430__t3 \$430 16.7641747213
* device instance _430_t4 r0 *1 0,0
R_430_t4 \$430__t4 \$430 9.52844849363
* device instance _430 r0 *1 0,0
C_430 \$430 vsubs 7.83841e-16
* device instance _433_t0 r0 *1 0,0
R_433_t0 \$433__t0 \$433 17.162141452
* device instance _433_t1 r0 *1 0,0
R_433_t1 \$433__t1 \$433 14.0706287935
* device instance _433_t2 r0 *1 0,0
R_433_t2 \$433__t2 \$433 13.6875065396
* device instance _433_t3 r0 *1 0,0
R_433_t3 \$433__t3 \$433 16.7641747213
* device instance _433_t4 r0 *1 0,0
R_433_t4 \$433__t4 \$433 9.52844849363
* device instance _433 r0 *1 0,0
C_433 \$433 vsubs 7.83841e-16
* device instance _436_t0 r0 *1 0,0
R_436_t0 \$436__t0 \$436 17.162141452
* device instance _436_t1 r0 *1 0,0
R_436_t1 \$436__t1 \$436 14.0706287935
* device instance _436_t2 r0 *1 0,0
R_436_t2 \$436__t2 \$436 13.6875065396
* device instance _436_t3 r0 *1 0,0
R_436_t3 \$436__t3 \$436 16.7641747213
* device instance _436_t4 r0 *1 0,0
R_436_t4 \$436__t4 \$436 9.52844849363
* device instance _436 r0 *1 0,0
C_436 \$436 vsubs 7.83841e-16
* device instance _439_t0 r0 *1 0,0
R_439_t0 \$439__t0 \$439 17.162141452
* device instance _439_t1 r0 *1 0,0
R_439_t1 \$439__t1 \$439 14.0706287935
* device instance _439_t2 r0 *1 0,0
R_439_t2 \$439__t2 \$439 13.6875065396
* device instance _439_t3 r0 *1 0,0
R_439_t3 \$439__t3 \$439 16.7641747213
* device instance _439_t4 r0 *1 0,0
R_439_t4 \$439__t4 \$439 9.52844849363
* device instance _439 r0 *1 0,0
C_439 \$439 vsubs 7.83841e-16
* device instance _44_t0 r0 *1 0,0
R_44_t0 \$44__t0 \$44 14.0706287935
* device instance _44_t1 r0 *1 0,0
R_44_t1 \$44__t1 \$44 17.162141452
* device instance _44_t2 r0 *1 0,0
R_44_t2 \$44__t2 \$44 13.6875065396
* device instance _44_t3 r0 *1 0,0
R_44_t3 \$44__t3 \$44 9.52844849363
* device instance _44_t4 r0 *1 0,0
R_44_t4 \$44__t4 \$44 16.7641747213
* device instance _44 r0 *1 0,0
C_44 \$44 vsubs 7.92193e-16
* device instance _442_t0 r0 *1 0,0
R_442_t0 \$442__t0 \$442 17.162141452
* device instance _442_t1 r0 *1 0,0
R_442_t1 \$442__t1 \$442 14.0706287935
* device instance _442_t2 r0 *1 0,0
R_442_t2 \$442__t2 \$442 13.6875065396
* device instance _442_t3 r0 *1 0,0
R_442_t3 \$442__t3 \$442 16.7641747213
* device instance _442_t4 r0 *1 0,0
R_442_t4 \$442__t4 \$442 9.52844849363
* device instance _442 r0 *1 0,0
C_442 \$442 vsubs 7.83841e-16
* device instance _445_t0 r0 *1 0,0
R_445_t0 \$445__t0 \$445 17.162141452
* device instance _445_t1 r0 *1 0,0
R_445_t1 \$445__t1 \$445 14.0706287935
* device instance _445_t2 r0 *1 0,0
R_445_t2 \$445__t2 \$445 13.6875065396
* device instance _445_t3 r0 *1 0,0
R_445_t3 \$445__t3 \$445 16.7641747213
* device instance _445_t4 r0 *1 0,0
R_445_t4 \$445__t4 \$445 9.52844849363
* device instance _445 r0 *1 0,0
C_445 \$445 vsubs 7.83841e-16
* device instance _448_t0 r0 *1 0,0
R_448_t0 \$448__t0 \$448 17.162141452
* device instance _448_t1 r0 *1 0,0
R_448_t1 \$448__t1 \$448 14.0706287935
* device instance _448_t2 r0 *1 0,0
R_448_t2 \$448__t2 \$448 13.6875065396
* device instance _448_t3 r0 *1 0,0
R_448_t3 \$448__t3 \$448 16.7641747213
* device instance _448_t4 r0 *1 0,0
R_448_t4 \$448__t4 \$448 9.52844849363
* device instance _448 r0 *1 0,0
C_448 \$448 vsubs 7.83841e-16
* device instance _45_t0 r0 *1 0,0
R_45_t0 \$45__t0 \$45 14.0706287935
* device instance _45_t1 r0 *1 0,0
R_45_t1 \$45__t1 \$45 17.162141452
* device instance _45_t2 r0 *1 0,0
R_45_t2 \$45__t2 \$45 13.6875065396
* device instance _45_t3 r0 *1 0,0
R_45_t3 \$45__t3 \$45 9.52844849363
* device instance _45_t4 r0 *1 0,0
R_45_t4 \$45__t4 \$45 16.7641747213
* device instance _45 r0 *1 0,0
C_45 \$45 vsubs 7.92193e-16
* device instance _451_t0 r0 *1 0,0
R_451_t0 \$451__t0 \$451 17.162141452
* device instance _451_t1 r0 *1 0,0
R_451_t1 \$451__t1 \$451 14.0706287935
* device instance _451_t2 r0 *1 0,0
R_451_t2 \$451__t2 \$451 13.6875065396
* device instance _451_t3 r0 *1 0,0
R_451_t3 \$451__t3 \$451 16.7641747213
* device instance _451_t4 r0 *1 0,0
R_451_t4 \$451__t4 \$451 9.52844849363
* device instance _451 r0 *1 0,0
C_451 \$451 vsubs 7.83841e-16
* device instance _454_t0 r0 *1 0,0
R_454_t0 \$454__t0 \$454 17.162141452
* device instance _454_t1 r0 *1 0,0
R_454_t1 \$454__t1 \$454 14.0706287935
* device instance _454_t2 r0 *1 0,0
R_454_t2 \$454__t2 \$454 13.6875065396
* device instance _454_t3 r0 *1 0,0
R_454_t3 \$454__t3 \$454 16.7641747213
* device instance _454_t4 r0 *1 0,0
R_454_t4 \$454__t4 \$454 9.52844849363
* device instance _454 r0 *1 0,0
C_454 \$454 vsubs 7.83841e-16
* device instance _457_t0 r0 *1 0,0
R_457_t0 \$457__t0 \$457 17.162141452
* device instance _457_t1 r0 *1 0,0
R_457_t1 \$457__t1 \$457 14.0706287935
* device instance _457_t2 r0 *1 0,0
R_457_t2 \$457__t2 \$457 13.6875065396
* device instance _457_t3 r0 *1 0,0
R_457_t3 \$457__t3 \$457 16.7641747213
* device instance _457_t4 r0 *1 0,0
R_457_t4 \$457__t4 \$457 9.52844849363
* device instance _457 r0 *1 0,0
C_457 \$457 vsubs 7.83841e-16
* device instance _46_t0 r0 *1 0,0
R_46_t0 \$46__t0 \$46 14.0706287935
* device instance _46_t1 r0 *1 0,0
R_46_t1 \$46__t1 \$46 17.162141452
* device instance _46_t2 r0 *1 0,0
R_46_t2 \$46__t2 \$46 13.6875065396
* device instance _46_t3 r0 *1 0,0
R_46_t3 \$46__t3 \$46 9.52844849363
* device instance _46_t4 r0 *1 0,0
R_46_t4 \$46__t4 \$46 16.7641747213
* device instance _46 r0 *1 0,0
C_46 \$46 vsubs 7.92193e-16
* device instance _460_t0 r0 *1 0,0
R_460_t0 \$460__t0 \$460 17.162141452
* device instance _460_t1 r0 *1 0,0
R_460_t1 \$460__t1 \$460 14.0706287935
* device instance _460_t2 r0 *1 0,0
R_460_t2 \$460__t2 \$460 13.6875065396
* device instance _460_t3 r0 *1 0,0
R_460_t3 \$460__t3 \$460 16.7641747213
* device instance _460_t4 r0 *1 0,0
R_460_t4 \$460__t4 \$460 9.52844849363
* device instance _460 r0 *1 0,0
C_460 \$460 vsubs 7.83841e-16
* device instance _463_t0 r0 *1 0,0
R_463_t0 \$463__t0 \$463 17.162141452
* device instance _463_t1 r0 *1 0,0
R_463_t1 \$463__t1 \$463 14.0706287935
* device instance _463_t2 r0 *1 0,0
R_463_t2 \$463__t2 \$463 13.6875065396
* device instance _463_t3 r0 *1 0,0
R_463_t3 \$463__t3 \$463 16.7641747213
* device instance _463_t4 r0 *1 0,0
R_463_t4 \$463__t4 \$463 9.52844849363
* device instance _463 r0 *1 0,0
C_463 \$463 vsubs 7.83841e-16
* device instance _466_t0 r0 *1 0,0
R_466_t0 \$466__t0 \$466 17.162141452
* device instance _466_t1 r0 *1 0,0
R_466_t1 \$466__t1 \$466 14.0706287935
* device instance _466_t2 r0 *1 0,0
R_466_t2 \$466__t2 \$466 13.6875065396
* device instance _466_t3 r0 *1 0,0
R_466_t3 \$466__t3 \$466 16.7641747213
* device instance _466_t4 r0 *1 0,0
R_466_t4 \$466__t4 \$466 9.52844849363
* device instance _466 r0 *1 0,0
C_466 \$466 vsubs 7.83841e-16
* device instance _469_t0 r0 *1 0,0
R_469_t0 \$469__t0 \$469 17.162141452
* device instance _469_t1 r0 *1 0,0
R_469_t1 \$469__t1 \$469 14.0706287935
* device instance _469_t2 r0 *1 0,0
R_469_t2 \$469__t2 \$469 13.6875065396
* device instance _469_t3 r0 *1 0,0
R_469_t3 \$469__t3 \$469 16.7641747213
* device instance _469_t4 r0 *1 0,0
R_469_t4 \$469__t4 \$469 9.52844849363
* device instance _469 r0 *1 0,0
C_469 \$469 vsubs 7.83841e-16
* device instance _47_t0 r0 *1 0,0
R_47_t0 \$47__t0 \$47 14.0706287935
* device instance _47_t1 r0 *1 0,0
R_47_t1 \$47__t1 \$47 17.162141452
* device instance _47_t2 r0 *1 0,0
R_47_t2 \$47__t2 \$47 13.6875065396
* device instance _47_t3 r0 *1 0,0
R_47_t3 \$47__t3 \$47 9.52844849363
* device instance _47_t4 r0 *1 0,0
R_47_t4 \$47__t4 \$47 16.7641747213
* device instance _47 r0 *1 0,0
C_47 \$47 vsubs 7.92193e-16
* device instance _472_t0 r0 *1 0,0
R_472_t0 \$472__t0 \$472 17.162141452
* device instance _472_t1 r0 *1 0,0
R_472_t1 \$472__t1 \$472 14.0706287935
* device instance _472_t2 r0 *1 0,0
R_472_t2 \$472__t2 \$472 13.6875065396
* device instance _472_t3 r0 *1 0,0
R_472_t3 \$472__t3 \$472 16.7641747213
* device instance _472_t4 r0 *1 0,0
R_472_t4 \$472__t4 \$472 9.52844849363
* device instance _472 r0 *1 0,0
C_472 \$472 vsubs 7.83841e-16
* device instance _475_t0 r0 *1 0,0
R_475_t0 \$475__t0 \$475 17.162141452
* device instance _475_t1 r0 *1 0,0
R_475_t1 \$475__t1 \$475 14.0706287935
* device instance _475_t2 r0 *1 0,0
R_475_t2 \$475__t2 \$475 13.6875065396
* device instance _475_t3 r0 *1 0,0
R_475_t3 \$475__t3 \$475 16.7641747213
* device instance _475_t4 r0 *1 0,0
R_475_t4 \$475__t4 \$475 9.52844849363
* device instance _475 r0 *1 0,0
C_475 \$475 vsubs 7.83841e-16
* device instance _478_t0 r0 *1 0,0
R_478_t0 \$478__t0 \$478 17.162141452
* device instance _478_t1 r0 *1 0,0
R_478_t1 \$478__t1 \$478 14.0706287935
* device instance _478_t2 r0 *1 0,0
R_478_t2 \$478__t2 \$478 13.6875065396
* device instance _478_t3 r0 *1 0,0
R_478_t3 \$478__t3 \$478 16.7641747213
* device instance _478_t4 r0 *1 0,0
R_478_t4 \$478__t4 \$478 9.52844849363
* device instance _478 r0 *1 0,0
C_478 \$478 vsubs 7.83841e-16
* device instance _48_t0 r0 *1 0,0
R_48_t0 \$48__t0 \$48 14.0706287935
* device instance _48_t1 r0 *1 0,0
R_48_t1 \$48__t1 \$48 17.162141452
* device instance _48_t2 r0 *1 0,0
R_48_t2 \$48__t2 \$48 13.6875065396
* device instance _48_t3 r0 *1 0,0
R_48_t3 \$48__t3 \$48 9.52844849363
* device instance _48_t4 r0 *1 0,0
R_48_t4 \$48__t4 \$48 16.7641747213
* device instance _48 r0 *1 0,0
C_48 \$48 vsubs 7.92193e-16
* device instance _481_t0 r0 *1 0,0
R_481_t0 \$481__t0 \$481 17.162141452
* device instance _481_t1 r0 *1 0,0
R_481_t1 \$481__t1 \$481 14.0706287935
* device instance _481_t2 r0 *1 0,0
R_481_t2 \$481__t2 \$481 13.6875065396
* device instance _481_t3 r0 *1 0,0
R_481_t3 \$481__t3 \$481 16.7641747213
* device instance _481_t4 r0 *1 0,0
R_481_t4 \$481__t4 \$481 9.52844849363
* device instance _481 r0 *1 0,0
C_481 \$481 vsubs 7.83841e-16
* device instance _484_t0 r0 *1 0,0
R_484_t0 \$484__t0 \$484 17.162141452
* device instance _484_t1 r0 *1 0,0
R_484_t1 \$484__t1 \$484 14.0706287935
* device instance _484_t2 r0 *1 0,0
R_484_t2 \$484__t2 \$484 13.6875065396
* device instance _484_t3 r0 *1 0,0
R_484_t3 \$484__t3 \$484 16.7641747213
* device instance _484_t4 r0 *1 0,0
R_484_t4 \$484__t4 \$484 9.52844849363
* device instance _484 r0 *1 0,0
C_484 \$484 vsubs 7.83841e-16
* device instance _487_t0 r0 *1 0,0
R_487_t0 \$487__t0 \$487 17.162141452
* device instance _487_t1 r0 *1 0,0
R_487_t1 \$487__t1 \$487 14.0706287935
* device instance _487_t2 r0 *1 0,0
R_487_t2 \$487__t2 \$487 13.6875065396
* device instance _487_t3 r0 *1 0,0
R_487_t3 \$487__t3 \$487 16.7641747213
* device instance _487_t4 r0 *1 0,0
R_487_t4 \$487__t4 \$487 9.52844849363
* device instance _487 r0 *1 0,0
C_487 \$487 vsubs 7.83841e-16
* device instance _49_t0 r0 *1 0,0
R_49_t0 \$49__t0 \$49 14.0706287935
* device instance _49_t1 r0 *1 0,0
R_49_t1 \$49__t1 \$49 17.162141452
* device instance _49_t2 r0 *1 0,0
R_49_t2 \$49__t2 \$49 13.6875065396
* device instance _49_t3 r0 *1 0,0
R_49_t3 \$49__t3 \$49 9.52844849363
* device instance _49_t4 r0 *1 0,0
R_49_t4 \$49__t4 \$49 16.7641747213
* device instance _49 r0 *1 0,0
C_49 \$49 vsubs 7.92193e-16
* device instance _490_t0 r0 *1 0,0
R_490_t0 \$490__t0 \$490 17.162141452
* device instance _490_t1 r0 *1 0,0
R_490_t1 \$490__t1 \$490 14.0706287935
* device instance _490_t2 r0 *1 0,0
R_490_t2 \$490__t2 \$490 13.6875065396
* device instance _490_t3 r0 *1 0,0
R_490_t3 \$490__t3 \$490 16.7641747213
* device instance _490_t4 r0 *1 0,0
R_490_t4 \$490__t4 \$490 9.52844849363
* device instance _490 r0 *1 0,0
C_490 \$490 vsubs 7.83841e-16
* device instance _493_t0 r0 *1 0,0
R_493_t0 \$493__t0 \$493 17.162141452
* device instance _493_t1 r0 *1 0,0
R_493_t1 \$493__t1 \$493 14.0706287935
* device instance _493_t2 r0 *1 0,0
R_493_t2 \$493__t2 \$493 13.6875065396
* device instance _493_t3 r0 *1 0,0
R_493_t3 \$493__t3 \$493 16.7641747213
* device instance _493_t4 r0 *1 0,0
R_493_t4 \$493__t4 \$493 9.52844849363
* device instance _493 r0 *1 0,0
C_493 \$493 vsubs 7.83841e-16
* device instance _496_t0 r0 *1 0,0
R_496_t0 \$496__t0 \$496 17.162141452
* device instance _496_t1 r0 *1 0,0
R_496_t1 \$496__t1 \$496 14.0706287935
* device instance _496_t2 r0 *1 0,0
R_496_t2 \$496__t2 \$496 13.6875065396
* device instance _496_t3 r0 *1 0,0
R_496_t3 \$496__t3 \$496 16.7641747213
* device instance _496_t4 r0 *1 0,0
R_496_t4 \$496__t4 \$496 9.52844849363
* device instance _496 r0 *1 0,0
C_496 \$496 vsubs 7.83841e-16
* device instance _499_t0 r0 *1 0,0
R_499_t0 \$499__t0 \$499 17.162141452
* device instance _499_t1 r0 *1 0,0
R_499_t1 \$499__t1 \$499 14.0706287935
* device instance _499_t2 r0 *1 0,0
R_499_t2 \$499__t2 \$499 13.6875065396
* device instance _499_t3 r0 *1 0,0
R_499_t3 \$499__t3 \$499 16.7641747213
* device instance _499_t4 r0 *1 0,0
R_499_t4 \$499__t4 \$499 9.52844849363
* device instance _499 r0 *1 0,0
C_499 \$499 vsubs 7.83841e-16
* device instance _5_t0 r0 *1 0,0
R_5_t0 \$5__t0 \$5 14.0706287935
* device instance _5_t1 r0 *1 0,0
R_5_t1 \$5__t1 \$5 17.162141452
* device instance _5_t2 r0 *1 0,0
R_5_t2 \$5__t2 \$5 13.6875065396
* device instance _5_t3 r0 *1 0,0
R_5_t3 \$5__t3 \$5 9.52844849363
* device instance _5_t4 r0 *1 0,0
R_5_t4 \$5__t4 \$5 16.7641747213
* device instance _5 r0 *1 0,0
C_5 \$5 vsubs 7.92193e-16
* device instance _50_t0 r0 *1 0,0
R_50_t0 \$50__t0 \$50 14.0706287935
* device instance _50_t1 r0 *1 0,0
R_50_t1 \$50__t1 \$50 17.162141452
* device instance _50_t2 r0 *1 0,0
R_50_t2 \$50__t2 \$50 13.6875065396
* device instance _50_t3 r0 *1 0,0
R_50_t3 \$50__t3 \$50 9.52844849363
* device instance _50_t4 r0 *1 0,0
R_50_t4 \$50__t4 \$50 16.7641747213
* device instance _50 r0 *1 0,0
C_50 \$50 vsubs 7.92193e-16
* device instance _502_t0 r0 *1 0,0
R_502_t0 \$502__t0 \$502 17.162141452
* device instance _502_t1 r0 *1 0,0
R_502_t1 \$502__t1 \$502 14.0706287935
* device instance _502_t2 r0 *1 0,0
R_502_t2 \$502__t2 \$502 13.6875065396
* device instance _502_t3 r0 *1 0,0
R_502_t3 \$502__t3 \$502 16.7641747213
* device instance _502_t4 r0 *1 0,0
R_502_t4 \$502__t4 \$502 9.52844849363
* device instance _502 r0 *1 0,0
C_502 \$502 vsubs 7.83841e-16
* device instance _505_t0 r0 *1 0,0
R_505_t0 \$505__t0 \$505 17.162141452
* device instance _505_t1 r0 *1 0,0
R_505_t1 \$505__t1 \$505 14.0706287935
* device instance _505_t2 r0 *1 0,0
R_505_t2 \$505__t2 \$505 13.6875065396
* device instance _505_t3 r0 *1 0,0
R_505_t3 \$505__t3 \$505 16.7641747213
* device instance _505_t4 r0 *1 0,0
R_505_t4 \$505__t4 \$505 9.52844849363
* device instance _505 r0 *1 0,0
C_505 \$505 vsubs 7.83841e-16
* device instance _508_t0 r0 *1 0,0
R_508_t0 \$508__t0 \$508 17.162141452
* device instance _508_t1 r0 *1 0,0
R_508_t1 \$508__t1 \$508 14.0706287935
* device instance _508_t2 r0 *1 0,0
R_508_t2 \$508__t2 \$508 13.6875065396
* device instance _508_t3 r0 *1 0,0
R_508_t3 \$508__t3 \$508 16.7641747213
* device instance _508_t4 r0 *1 0,0
R_508_t4 \$508__t4 \$508 9.52844849363
* device instance _508 r0 *1 0,0
C_508 \$508 vsubs 7.83841e-16
* device instance _51_t0 r0 *1 0,0
R_51_t0 \$51__t0 \$51 14.0706287935
* device instance _51_t1 r0 *1 0,0
R_51_t1 \$51__t1 \$51 17.162141452
* device instance _51_t2 r0 *1 0,0
R_51_t2 \$51__t2 \$51 13.6875065396
* device instance _51_t3 r0 *1 0,0
R_51_t3 \$51__t3 \$51 9.52844849363
* device instance _51_t4 r0 *1 0,0
R_51_t4 \$51__t4 \$51 16.7641747213
* device instance _51 r0 *1 0,0
C_51 \$51 vsubs 7.92193e-16
* device instance _511_t0 r0 *1 0,0
R_511_t0 \$511__t0 \$511 17.162141452
* device instance _511_t1 r0 *1 0,0
R_511_t1 \$511__t1 \$511 14.0706287935
* device instance _511_t2 r0 *1 0,0
R_511_t2 \$511__t2 \$511 13.6875065396
* device instance _511_t3 r0 *1 0,0
R_511_t3 \$511__t3 \$511 16.7641747213
* device instance _511_t4 r0 *1 0,0
R_511_t4 \$511__t4 \$511 9.52844849363
* device instance _511 r0 *1 0,0
C_511 \$511 vsubs 7.83841e-16
* device instance _514_t0 r0 *1 0,0
R_514_t0 \$514__t0 \$514 17.162141452
* device instance _514_t1 r0 *1 0,0
R_514_t1 \$514__t1 \$514 14.0706287935
* device instance _514_t2 r0 *1 0,0
R_514_t2 \$514__t2 \$514 13.6875065396
* device instance _514_t3 r0 *1 0,0
R_514_t3 \$514__t3 \$514 16.7641747213
* device instance _514_t4 r0 *1 0,0
R_514_t4 \$514__t4 \$514 9.52844849363
* device instance _514 r0 *1 0,0
C_514 \$514 vsubs 7.83841e-16
* device instance _52_t0 r0 *1 0,0
R_52_t0 \$52__t0 \$52 14.0706287935
* device instance _52_t1 r0 *1 0,0
R_52_t1 \$52__t1 \$52 17.162141452
* device instance _52_t2 r0 *1 0,0
R_52_t2 \$52__t2 \$52 13.6875065396
* device instance _52_t3 r0 *1 0,0
R_52_t3 \$52__t3 \$52 9.52844849363
* device instance _52_t4 r0 *1 0,0
R_52_t4 \$52__t4 \$52 16.7641747213
* device instance _52 r0 *1 0,0
C_52 \$52 vsubs 7.92193e-16
* device instance _53_t0 r0 *1 0,0
R_53_t0 \$53__t0 \$53 14.0706287935
* device instance _53_t1 r0 *1 0,0
R_53_t1 \$53__t1 \$53 17.162141452
* device instance _53_t2 r0 *1 0,0
R_53_t2 \$53__t2 \$53 13.6875065396
* device instance _53_t3 r0 *1 0,0
R_53_t3 \$53__t3 \$53 9.52844849363
* device instance _53_t4 r0 *1 0,0
R_53_t4 \$53__t4 \$53 16.7641747213
* device instance _53 r0 *1 0,0
C_53 \$53 vsubs 7.92193e-16
* device instance _54_t0 r0 *1 0,0
R_54_t0 \$54__t0 \$54 14.0706287935
* device instance _54_t1 r0 *1 0,0
R_54_t1 \$54__t1 \$54 17.162141452
* device instance _54_t2 r0 *1 0,0
R_54_t2 \$54__t2 \$54 13.6875065396
* device instance _54_t3 r0 *1 0,0
R_54_t3 \$54__t3 \$54 9.52844849363
* device instance _54_t4 r0 *1 0,0
R_54_t4 \$54__t4 \$54 16.7641747213
* device instance _54 r0 *1 0,0
C_54 \$54 vsubs 7.92193e-16
* device instance _55_t0 r0 *1 0,0
R_55_t0 \$55__t0 \$55 14.0706287935
* device instance _55_t1 r0 *1 0,0
R_55_t1 \$55__t1 \$55 17.162141452
* device instance _55_t2 r0 *1 0,0
R_55_t2 \$55__t2 \$55 13.6875065396
* device instance _55_t3 r0 *1 0,0
R_55_t3 \$55__t3 \$55 9.52844849363
* device instance _55_t4 r0 *1 0,0
R_55_t4 \$55__t4 \$55 16.7641747213
* device instance _55 r0 *1 0,0
C_55 \$55 vsubs 7.92193e-16
* device instance _56_t0 r0 *1 0,0
R_56_t0 \$56__t0 \$56 14.0706287935
* device instance _56_t1 r0 *1 0,0
R_56_t1 \$56__t1 \$56 17.162141452
* device instance _56_t2 r0 *1 0,0
R_56_t2 \$56__t2 \$56 13.6875065396
* device instance _56_t3 r0 *1 0,0
R_56_t3 \$56__t3 \$56 9.52844849363
* device instance _56_t4 r0 *1 0,0
R_56_t4 \$56__t4 \$56 16.7641747213
* device instance _56 r0 *1 0,0
C_56 \$56 vsubs 7.92193e-16
* device instance _57_t0 r0 *1 0,0
R_57_t0 \$57__t0 \$57 14.0706287935
* device instance _57_t1 r0 *1 0,0
R_57_t1 \$57__t1 \$57 17.162141452
* device instance _57_t2 r0 *1 0,0
R_57_t2 \$57__t2 \$57 13.6875065396
* device instance _57_t3 r0 *1 0,0
R_57_t3 \$57__t3 \$57 9.52844849363
* device instance _57_t4 r0 *1 0,0
R_57_t4 \$57__t4 \$57 16.7641747213
* device instance _57 r0 *1 0,0
C_57 \$57 vsubs 7.92193e-16
* device instance _58_t0 r0 *1 0,0
R_58_t0 \$58__t0 \$58 14.0706287935
* device instance _58_t1 r0 *1 0,0
R_58_t1 \$58__t1 \$58 17.162141452
* device instance _58_t2 r0 *1 0,0
R_58_t2 \$58__t2 \$58 13.6875065396
* device instance _58_t3 r0 *1 0,0
R_58_t3 \$58__t3 \$58 9.52844849363
* device instance _58_t4 r0 *1 0,0
R_58_t4 \$58__t4 \$58 16.7641747213
* device instance _58 r0 *1 0,0
C_58 \$58 vsubs 7.92193e-16
* device instance _59_t0 r0 *1 0,0
R_59_t0 \$59__t0 \$59 14.0706287935
* device instance _59_t1 r0 *1 0,0
R_59_t1 \$59__t1 \$59 17.162141452
* device instance _59_t2 r0 *1 0,0
R_59_t2 \$59__t2 \$59 13.6875065396
* device instance _59_t3 r0 *1 0,0
R_59_t3 \$59__t3 \$59 9.52844849363
* device instance _59_t4 r0 *1 0,0
R_59_t4 \$59__t4 \$59 16.7641747213
* device instance _59 r0 *1 0,0
C_59 \$59 vsubs 7.92193e-16
* device instance _6_t0 r0 *1 0,0
R_6_t0 \$6__t0 \$6 14.0706287935
* device instance _6_t1 r0 *1 0,0
R_6_t1 \$6__t1 \$6 17.162141452
* device instance _6_t2 r0 *1 0,0
R_6_t2 \$6__t2 \$6 13.6875065396
* device instance _6_t3 r0 *1 0,0
R_6_t3 \$6__t3 \$6 9.52844849363
* device instance _6_t4 r0 *1 0,0
R_6_t4 \$6__t4 \$6 16.7641747213
* device instance _6 r0 *1 0,0
C_6 \$6 vsubs 7.92193e-16
* device instance _60_t0 r0 *1 0,0
R_60_t0 \$60__t0 \$60 14.0706287935
* device instance _60_t1 r0 *1 0,0
R_60_t1 \$60__t1 \$60 17.162141452
* device instance _60_t2 r0 *1 0,0
R_60_t2 \$60__t2 \$60 13.6875065396
* device instance _60_t3 r0 *1 0,0
R_60_t3 \$60__t3 \$60 9.52844849363
* device instance _60_t4 r0 *1 0,0
R_60_t4 \$60__t4 \$60 16.7641747213
* device instance _60 r0 *1 0,0
C_60 \$60 vsubs 7.92193e-16
* device instance _61_t0 r0 *1 0,0
R_61_t0 \$61__t0 \$61 14.0706287935
* device instance _61_t1 r0 *1 0,0
R_61_t1 \$61__t1 \$61 17.162141452
* device instance _61_t2 r0 *1 0,0
R_61_t2 \$61__t2 \$61 13.6875065396
* device instance _61_t3 r0 *1 0,0
R_61_t3 \$61__t3 \$61 9.52844849363
* device instance _61_t4 r0 *1 0,0
R_61_t4 \$61__t4 \$61 16.7641747213
* device instance _61 r0 *1 0,0
C_61 \$61 vsubs 7.92193e-16
* device instance _62_t0 r0 *1 0,0
R_62_t0 \$62__t0 \$62 14.0706287935
* device instance _62_t1 r0 *1 0,0
R_62_t1 \$62__t1 \$62 17.162141452
* device instance _62_t2 r0 *1 0,0
R_62_t2 \$62__t2 \$62 13.6875065396
* device instance _62_t3 r0 *1 0,0
R_62_t3 \$62__t3 \$62 9.52844849363
* device instance _62_t4 r0 *1 0,0
R_62_t4 \$62__t4 \$62 16.7641747213
* device instance _62 r0 *1 0,0
C_62 \$62 vsubs 7.92193e-16
* device instance _63_t0 r0 *1 0,0
R_63_t0 \$63__t0 \$63 14.0706287935
* device instance _63_t1 r0 *1 0,0
R_63_t1 \$63__t1 \$63 17.162141452
* device instance _63_t2 r0 *1 0,0
R_63_t2 \$63__t2 \$63 13.6875065396
* device instance _63_t3 r0 *1 0,0
R_63_t3 \$63__t3 \$63 9.52844849363
* device instance _63_t4 r0 *1 0,0
R_63_t4 \$63__t4 \$63 16.7641747213
* device instance _63 r0 *1 0,0
C_63 \$63 vsubs 7.92193e-16
* device instance _64_t0 r0 *1 0,0
R_64_t0 \$64__t0 \$64 14.0706287935
* device instance _64_t1 r0 *1 0,0
R_64_t1 \$64__t1 \$64 17.162141452
* device instance _64_t2 r0 *1 0,0
R_64_t2 \$64__t2 \$64 13.6875065396
* device instance _64_t3 r0 *1 0,0
R_64_t3 \$64__t3 \$64 9.52844849363
* device instance _64_t4 r0 *1 0,0
R_64_t4 \$64__t4 \$64 16.7641747213
* device instance _64 r0 *1 0,0
C_64 \$64 vsubs 7.92193e-16
* device instance _65_t0 r0 *1 0,0
R_65_t0 \$65__t0 \$65 14.0706287935
* device instance _65_t1 r0 *1 0,0
R_65_t1 \$65__t1 \$65 17.162141452
* device instance _65_t2 r0 *1 0,0
R_65_t2 \$65__t2 \$65 13.6875065396
* device instance _65_t3 r0 *1 0,0
R_65_t3 \$65__t3 \$65 9.52844849363
* device instance _65_t4 r0 *1 0,0
R_65_t4 \$65__t4 \$65 16.7641747213
* device instance _65 r0 *1 0,0
C_65 \$65 vsubs 7.92193e-16
* device instance _66_t0 r0 *1 0,0
R_66_t0 \$66__t0 \$66 14.0706287935
* device instance _66_t1 r0 *1 0,0
R_66_t1 \$66__t1 \$66 17.162141452
* device instance _66_t2 r0 *1 0,0
R_66_t2 \$66__t2 \$66 13.6875065396
* device instance _66_t3 r0 *1 0,0
R_66_t3 \$66__t3 \$66 9.52844849363
* device instance _66_t4 r0 *1 0,0
R_66_t4 \$66__t4 \$66 16.7641747213
* device instance _66 r0 *1 0,0
C_66 \$66 vsubs 7.92193e-16
* device instance _67_t0 r0 *1 0,0
R_67_t0 \$67__t0 \$67 14.0706287935
* device instance _67_t1 r0 *1 0,0
R_67_t1 \$67__t1 \$67 17.162141452
* device instance _67_t2 r0 *1 0,0
R_67_t2 \$67__t2 \$67 13.6875065396
* device instance _67_t3 r0 *1 0,0
R_67_t3 \$67__t3 \$67 9.52844849363
* device instance _67_t4 r0 *1 0,0
R_67_t4 \$67__t4 \$67 16.7641747213
* device instance _67 r0 *1 0,0
C_67 \$67 vsubs 7.92193e-16
* device instance _68_t0 r0 *1 0,0
R_68_t0 \$68__t0 \$68 14.0706287935
* device instance _68_t1 r0 *1 0,0
R_68_t1 \$68__t1 \$68 17.162141452
* device instance _68_t2 r0 *1 0,0
R_68_t2 \$68__t2 \$68 13.6875065396
* device instance _68_t3 r0 *1 0,0
R_68_t3 \$68__t3 \$68 9.52844849363
* device instance _68_t4 r0 *1 0,0
R_68_t4 \$68__t4 \$68 16.7641747213
* device instance _68 r0 *1 0,0
C_68 \$68 vsubs 7.92193e-16
* device instance _69_t0 r0 *1 0,0
R_69_t0 \$69__t0 \$69 14.0706287935
* device instance _69_t1 r0 *1 0,0
R_69_t1 \$69__t1 \$69 17.162141452
* device instance _69_t2 r0 *1 0,0
R_69_t2 \$69__t2 \$69 13.6875065396
* device instance _69_t3 r0 *1 0,0
R_69_t3 \$69__t3 \$69 9.52844849363
* device instance _69_t4 r0 *1 0,0
R_69_t4 \$69__t4 \$69 16.7641747213
* device instance _69 r0 *1 0,0
C_69 \$69 vsubs 7.92193e-16
* device instance _7_t0 r0 *1 0,0
R_7_t0 \$7__t0 \$7 14.0706287935
* device instance _7_t1 r0 *1 0,0
R_7_t1 \$7__t1 \$7 17.162141452
* device instance _7_t2 r0 *1 0,0
R_7_t2 \$7__t2 \$7 13.6875065396
* device instance _7_t3 r0 *1 0,0
R_7_t3 \$7__t3 \$7 9.52844849363
* device instance _7_t4 r0 *1 0,0
R_7_t4 \$7__t4 \$7 16.7641747213
* device instance _7 r0 *1 0,0
C_7 \$7 vsubs 7.92193e-16
* device instance _70_t0 r0 *1 0,0
R_70_t0 \$70__t0 \$70 14.0706287935
* device instance _70_t1 r0 *1 0,0
R_70_t1 \$70__t1 \$70 17.162141452
* device instance _70_t2 r0 *1 0,0
R_70_t2 \$70__t2 \$70 13.6875065396
* device instance _70_t3 r0 *1 0,0
R_70_t3 \$70__t3 \$70 9.52844849363
* device instance _70_t4 r0 *1 0,0
R_70_t4 \$70__t4 \$70 16.7641747213
* device instance _70 r0 *1 0,0
C_70 \$70 vsubs 7.92193e-16
* device instance _71_t0 r0 *1 0,0
R_71_t0 \$71__t0 \$71 14.0706287935
* device instance _71_t1 r0 *1 0,0
R_71_t1 \$71__t1 \$71 17.162141452
* device instance _71_t2 r0 *1 0,0
R_71_t2 \$71__t2 \$71 13.6875065396
* device instance _71_t3 r0 *1 0,0
R_71_t3 \$71__t3 \$71 9.52844849363
* device instance _71_t4 r0 *1 0,0
R_71_t4 \$71__t4 \$71 16.7641747213
* device instance _71 r0 *1 0,0
C_71 \$71 vsubs 7.92193e-16
* device instance _72_t0 r0 *1 0,0
R_72_t0 \$72__t0 \$72 14.0706287935
* device instance _72_t1 r0 *1 0,0
R_72_t1 \$72__t1 \$72 17.162141452
* device instance _72_t2 r0 *1 0,0
R_72_t2 \$72__t2 \$72 13.6875065396
* device instance _72_t3 r0 *1 0,0
R_72_t3 \$72__t3 \$72 9.52844849363
* device instance _72_t4 r0 *1 0,0
R_72_t4 \$72__t4 \$72 16.7641747213
* device instance _72 r0 *1 0,0
C_72 \$72 vsubs 7.92193e-16
* device instance _73_t0 r0 *1 0,0
R_73_t0 \$73__t0 \$73 14.0706287935
* device instance _73_t1 r0 *1 0,0
R_73_t1 \$73__t1 \$73 17.162141452
* device instance _73_t2 r0 *1 0,0
R_73_t2 \$73__t2 \$73 13.6875065396
* device instance _73_t3 r0 *1 0,0
R_73_t3 \$73__t3 \$73 9.52844849363
* device instance _73_t4 r0 *1 0,0
R_73_t4 \$73__t4 \$73 16.7641747213
* device instance _73 r0 *1 0,0
C_73 \$73 vsubs 7.92193e-16
* device instance _74_t0 r0 *1 0,0
R_74_t0 \$74__t0 \$74 14.0706287935
* device instance _74_t1 r0 *1 0,0
R_74_t1 \$74__t1 \$74 17.162141452
* device instance _74_t2 r0 *1 0,0
R_74_t2 \$74__t2 \$74 13.6875065396
* device instance _74_t3 r0 *1 0,0
R_74_t3 \$74__t3 \$74 9.52844849363
* device instance _74_t4 r0 *1 0,0
R_74_t4 \$74__t4 \$74 16.7641747213
* device instance _74 r0 *1 0,0
C_74 \$74 vsubs 7.92193e-16
* device instance _75_t0 r0 *1 0,0
R_75_t0 \$75__t0 \$75 14.0706287935
* device instance _75_t1 r0 *1 0,0
R_75_t1 \$75__t1 \$75 17.162141452
* device instance _75_t2 r0 *1 0,0
R_75_t2 \$75__t2 \$75 13.6875065396
* device instance _75_t3 r0 *1 0,0
R_75_t3 \$75__t3 \$75 9.52844849363
* device instance _75_t4 r0 *1 0,0
R_75_t4 \$75__t4 \$75 16.7641747213
* device instance _75 r0 *1 0,0
C_75 \$75 vsubs 7.92193e-16
* device instance _76_t0 r0 *1 0,0
R_76_t0 \$76__t0 \$76 14.0706287935
* device instance _76_t1 r0 *1 0,0
R_76_t1 \$76__t1 \$76 17.162141452
* device instance _76_t2 r0 *1 0,0
R_76_t2 \$76__t2 \$76 13.6875065396
* device instance _76_t3 r0 *1 0,0
R_76_t3 \$76__t3 \$76 9.52844849363
* device instance _76_t4 r0 *1 0,0
R_76_t4 \$76__t4 \$76 16.7641747213
* device instance _76 r0 *1 0,0
C_76 \$76 vsubs 7.92193e-16
* device instance _77_t0 r0 *1 0,0
R_77_t0 \$77__t0 \$77 14.0706287935
* device instance _77_t1 r0 *1 0,0
R_77_t1 \$77__t1 \$77 17.162141452
* device instance _77_t2 r0 *1 0,0
R_77_t2 \$77__t2 \$77 13.6875065396
* device instance _77_t3 r0 *1 0,0
R_77_t3 \$77__t3 \$77 9.52844849363
* device instance _77_t4 r0 *1 0,0
R_77_t4 \$77__t4 \$77 16.7641747213
* device instance _77 r0 *1 0,0
C_77 \$77 vsubs 7.92193e-16
* device instance _78_t0 r0 *1 0,0
R_78_t0 \$78__t0 \$78 14.0706287935
* device instance _78_t1 r0 *1 0,0
R_78_t1 \$78__t1 \$78 17.162141452
* device instance _78_t2 r0 *1 0,0
R_78_t2 \$78__t2 \$78 13.6875065396
* device instance _78_t3 r0 *1 0,0
R_78_t3 \$78__t3 \$78 9.52844849363
* device instance _78_t4 r0 *1 0,0
R_78_t4 \$78__t4 \$78 16.7641747213
* device instance _78 r0 *1 0,0
C_78 \$78 vsubs 7.92193e-16
* device instance _79_t0 r0 *1 0,0
R_79_t0 \$79__t0 \$79 14.0706287935
* device instance _79_t1 r0 *1 0,0
R_79_t1 \$79__t1 \$79 17.162141452
* device instance _79_t2 r0 *1 0,0
R_79_t2 \$79__t2 \$79 13.6875065396
* device instance _79_t3 r0 *1 0,0
R_79_t3 \$79__t3 \$79 9.52844849363
* device instance _79_t4 r0 *1 0,0
R_79_t4 \$79__t4 \$79 16.7641747213
* device instance _79 r0 *1 0,0
C_79 \$79 vsubs 7.92193e-16
* device instance _8_t0 r0 *1 0,0
R_8_t0 \$8__t0 \$8 14.0706287935
* device instance _8_t1 r0 *1 0,0
R_8_t1 \$8__t1 \$8 17.162141452
* device instance _8_t2 r0 *1 0,0
R_8_t2 \$8__t2 \$8 13.6875065396
* device instance _8_t3 r0 *1 0,0
R_8_t3 \$8__t3 \$8 9.52844849363
* device instance _8_t4 r0 *1 0,0
R_8_t4 \$8__t4 \$8 16.7641747213
* device instance _8 r0 *1 0,0
C_8 \$8 vsubs 7.92193e-16
* device instance _80_t0 r0 *1 0,0
R_80_t0 \$80__t0 \$80 14.0706287935
* device instance _80_t1 r0 *1 0,0
R_80_t1 \$80__t1 \$80 17.162141452
* device instance _80_t2 r0 *1 0,0
R_80_t2 \$80__t2 \$80 13.6875065396
* device instance _80_t3 r0 *1 0,0
R_80_t3 \$80__t3 \$80 9.52844849363
* device instance _80_t4 r0 *1 0,0
R_80_t4 \$80__t4 \$80 16.7641747213
* device instance _80 r0 *1 0,0
C_80 \$80 vsubs 7.92193e-16
* device instance _81_t0 r0 *1 0,0
R_81_t0 \$81__t0 \$81 14.0706287935
* device instance _81_t1 r0 *1 0,0
R_81_t1 \$81__t1 \$81 17.162141452
* device instance _81_t2 r0 *1 0,0
R_81_t2 \$81__t2 \$81 13.6875065396
* device instance _81_t3 r0 *1 0,0
R_81_t3 \$81__t3 \$81 9.52844849363
* device instance _81_t4 r0 *1 0,0
R_81_t4 \$81__t4 \$81 16.7641747213
* device instance _81 r0 *1 0,0
C_81 \$81 vsubs 7.92193e-16
* device instance _82_t0 r0 *1 0,0
R_82_t0 \$82__t0 \$82 14.0706287935
* device instance _82_t1 r0 *1 0,0
R_82_t1 \$82__t1 \$82 17.162141452
* device instance _82_t2 r0 *1 0,0
R_82_t2 \$82__t2 \$82 13.6875065396
* device instance _82_t3 r0 *1 0,0
R_82_t3 \$82__t3 \$82 9.52844849363
* device instance _82_t4 r0 *1 0,0
R_82_t4 \$82__t4 \$82 16.7641747213
* device instance _82 r0 *1 0,0
C_82 \$82 vsubs 7.92193e-16
* device instance _83_t0 r0 *1 0,0
R_83_t0 \$83__t0 \$83 14.0706287935
* device instance _83_t1 r0 *1 0,0
R_83_t1 \$83__t1 \$83 17.162141452
* device instance _83_t2 r0 *1 0,0
R_83_t2 \$83__t2 \$83 13.6875065396
* device instance _83_t3 r0 *1 0,0
R_83_t3 \$83__t3 \$83 9.52844849363
* device instance _83_t4 r0 *1 0,0
R_83_t4 \$83__t4 \$83 16.7641747213
* device instance _83 r0 *1 0,0
C_83 \$83 vsubs 7.92193e-16
* device instance _84_t0 r0 *1 0,0
R_84_t0 \$84__t0 \$84 14.0706287935
* device instance _84_t1 r0 *1 0,0
R_84_t1 \$84__t1 \$84 17.162141452
* device instance _84_t2 r0 *1 0,0
R_84_t2 \$84__t2 \$84 13.6875065396
* device instance _84_t3 r0 *1 0,0
R_84_t3 \$84__t3 \$84 9.52844849363
* device instance _84_t4 r0 *1 0,0
R_84_t4 \$84__t4 \$84 16.7641747213
* device instance _84 r0 *1 0,0
C_84 \$84 vsubs 7.92193e-16
* device instance _85_t0 r0 *1 0,0
R_85_t0 \$85__t0 \$85 14.0706287935
* device instance _85_t1 r0 *1 0,0
R_85_t1 \$85__t1 \$85 17.162141452
* device instance _85_t2 r0 *1 0,0
R_85_t2 \$85__t2 \$85 13.6875065396
* device instance _85_t3 r0 *1 0,0
R_85_t3 \$85__t3 \$85 9.52844849363
* device instance _85_t4 r0 *1 0,0
R_85_t4 \$85__t4 \$85 16.7641747213
* device instance _85 r0 *1 0,0
C_85 \$85 vsubs 7.92193e-16
* device instance _86_t0 r0 *1 0,0
R_86_t0 \$86__t0 \$86 14.0706287935
* device instance _86_t1 r0 *1 0,0
R_86_t1 \$86__t1 \$86 17.162141452
* device instance _86_t2 r0 *1 0,0
R_86_t2 \$86__t2 \$86 13.6875065396
* device instance _86_t3 r0 *1 0,0
R_86_t3 \$86__t3 \$86 9.52844849363
* device instance _86_t4 r0 *1 0,0
R_86_t4 \$86__t4 \$86 16.7641747213
* device instance _86 r0 *1 0,0
C_86 \$86 vsubs 7.92193e-16
* device instance _87_t0 r0 *1 0,0
R_87_t0 \$87__t0 \$87 14.0706287935
* device instance _87_t1 r0 *1 0,0
R_87_t1 \$87__t1 \$87 17.162141452
* device instance _87_t2 r0 *1 0,0
R_87_t2 \$87__t2 \$87 13.6875065396
* device instance _87_t3 r0 *1 0,0
R_87_t3 \$87__t3 \$87 9.52844849363
* device instance _87_t4 r0 *1 0,0
R_87_t4 \$87__t4 \$87 16.7641747213
* device instance _87 r0 *1 0,0
C_87 \$87 vsubs 7.92193e-16
* device instance _88_t0 r0 *1 0,0
R_88_t0 \$88__t0 \$88 14.0706287935
* device instance _88_t1 r0 *1 0,0
R_88_t1 \$88__t1 \$88 17.162141452
* device instance _88_t2 r0 *1 0,0
R_88_t2 \$88__t2 \$88 13.6875065396
* device instance _88_t3 r0 *1 0,0
R_88_t3 \$88__t3 \$88 9.52844849363
* device instance _88_t4 r0 *1 0,0
R_88_t4 \$88__t4 \$88 16.7641747213
* device instance _88 r0 *1 0,0
C_88 \$88 vsubs 7.92193e-16
* device instance _89_t0 r0 *1 0,0
R_89_t0 \$89__t0 \$89 14.0706287935
* device instance _89_t1 r0 *1 0,0
R_89_t1 \$89__t1 \$89 17.162141452
* device instance _89_t2 r0 *1 0,0
R_89_t2 \$89__t2 \$89 13.6875065396
* device instance _89_t3 r0 *1 0,0
R_89_t3 \$89__t3 \$89 9.52844849363
* device instance _89_t4 r0 *1 0,0
R_89_t4 \$89__t4 \$89 16.7641747213
* device instance _89 r0 *1 0,0
C_89 \$89 vsubs 7.92193e-16
* device instance _9_t0 r0 *1 0,0
R_9_t0 \$9__t0 \$9 14.0706287935
* device instance _9_t1 r0 *1 0,0
R_9_t1 \$9__t1 \$9 17.162141452
* device instance _9_t2 r0 *1 0,0
R_9_t2 \$9__t2 \$9 13.6875065396
* device instance _9_t3 r0 *1 0,0
R_9_t3 \$9__t3 \$9 9.52844849363
* device instance _9_t4 r0 *1 0,0
R_9_t4 \$9__t4 \$9 16.7641747213
* device instance _9 r0 *1 0,0
C_9 \$9 vsubs 7.92193e-16
* device instance _90_t0 r0 *1 0,0
R_90_t0 \$90__t0 \$90 14.0706287935
* device instance _90_t1 r0 *1 0,0
R_90_t1 \$90__t1 \$90 17.162141452
* device instance _90_t2 r0 *1 0,0
R_90_t2 \$90__t2 \$90 13.6875065396
* device instance _90_t3 r0 *1 0,0
R_90_t3 \$90__t3 \$90 9.52844849363
* device instance _90_t4 r0 *1 0,0
R_90_t4 \$90__t4 \$90 16.7641747213
* device instance _90 r0 *1 0,0
C_90 \$90 vsubs 7.92193e-16
* device instance _91_t0 r0 *1 0,0
R_91_t0 \$91__t0 \$91 14.0706287935
* device instance _91_t1 r0 *1 0,0
R_91_t1 \$91__t1 \$91 17.162141452
* device instance _91_t2 r0 *1 0,0
R_91_t2 \$91__t2 \$91 13.6875065396
* device instance _91_t3 r0 *1 0,0
R_91_t3 \$91__t3 \$91 9.52844849363
* device instance _91_t4 r0 *1 0,0
R_91_t4 \$91__t4 \$91 16.7641747213
* device instance _91 r0 *1 0,0
C_91 \$91 vsubs 7.92193e-16
* device instance _92_t0 r0 *1 0,0
R_92_t0 \$92__t0 \$92 14.0706287935
* device instance _92_t1 r0 *1 0,0
R_92_t1 \$92__t1 \$92 17.162141452
* device instance _92_t2 r0 *1 0,0
R_92_t2 \$92__t2 \$92 13.6875065396
* device instance _92_t3 r0 *1 0,0
R_92_t3 \$92__t3 \$92 9.52844849363
* device instance _92_t4 r0 *1 0,0
R_92_t4 \$92__t4 \$92 16.7641747213
* device instance _92 r0 *1 0,0
C_92 \$92 vsubs 7.92193e-16
* device instance _93_t0 r0 *1 0,0
R_93_t0 \$93__t0 \$93 14.0706287935
* device instance _93_t1 r0 *1 0,0
R_93_t1 \$93__t1 \$93 17.162141452
* device instance _93_t2 r0 *1 0,0
R_93_t2 \$93__t2 \$93 13.6875065396
* device instance _93_t3 r0 *1 0,0
R_93_t3 \$93__t3 \$93 9.52844849363
* device instance _93_t4 r0 *1 0,0
R_93_t4 \$93__t4 \$93 16.7641747213
* device instance _93 r0 *1 0,0
C_93 \$93 vsubs 7.92193e-16
* device instance _94_t0 r0 *1 0,0
R_94_t0 \$94__t0 \$94 14.0706287935
* device instance _94_t1 r0 *1 0,0
R_94_t1 \$94__t1 \$94 17.162141452
* device instance _94_t2 r0 *1 0,0
R_94_t2 \$94__t2 \$94 13.6875065396
* device instance _94_t3 r0 *1 0,0
R_94_t3 \$94__t3 \$94 9.52844849363
* device instance _94_t4 r0 *1 0,0
R_94_t4 \$94__t4 \$94 16.7641747213
* device instance _94 r0 *1 0,0
C_94 \$94 vsubs 7.92193e-16
* device instance _95_t0 r0 *1 0,0
R_95_t0 \$95__t0 \$95 14.0706287935
* device instance _95_t1 r0 *1 0,0
R_95_t1 \$95__t1 \$95 17.162141452
* device instance _95_t2 r0 *1 0,0
R_95_t2 \$95__t2 \$95 13.6875065396
* device instance _95_t3 r0 *1 0,0
R_95_t3 \$95__t3 \$95 9.52844849363
* device instance _95_t4 r0 *1 0,0
R_95_t4 \$95__t4 \$95 16.7641747213
* device instance _95 r0 *1 0,0
C_95 \$95 vsubs 7.92193e-16
* device instance _96_t0 r0 *1 0,0
R_96_t0 \$96__t0 \$96 14.0706287935
* device instance _96_t1 r0 *1 0,0
R_96_t1 \$96__t1 \$96 17.162141452
* device instance _96_t2 r0 *1 0,0
R_96_t2 \$96__t2 \$96 13.6875065396
* device instance _96_t3 r0 *1 0,0
R_96_t3 \$96__t3 \$96 9.52844849363
* device instance _96_t4 r0 *1 0,0
R_96_t4 \$96__t4 \$96 16.7641747213
* device instance _96 r0 *1 0,0
C_96 \$96 vsubs 7.92193e-16
* device instance _97_t0 r0 *1 0,0
R_97_t0 \$97__t0 \$97 14.0706287935
* device instance _97_t1 r0 *1 0,0
R_97_t1 \$97__t1 \$97 17.162141452
* device instance _97_t2 r0 *1 0,0
R_97_t2 \$97__t2 \$97 13.6875065396
* device instance _97_t3 r0 *1 0,0
R_97_t3 \$97__t3 \$97 9.52844849363
* device instance _97_t4 r0 *1 0,0
R_97_t4 \$97__t4 \$97 16.7641747213
* device instance _97 r0 *1 0,0
C_97 \$97 vsubs 7.92193e-16
* device instance _98_t0 r0 *1 0,0
R_98_t0 \$98__t0 \$98 14.0706287935
* device instance _98_t1 r0 *1 0,0
R_98_t1 \$98__t1 \$98 17.162141452
* device instance _98_t2 r0 *1 0,0
R_98_t2 \$98__t2 \$98 13.6875065396
* device instance _98_t3 r0 *1 0,0
R_98_t3 \$98__t3 \$98 9.52844849363
* device instance _98_t4 r0 *1 0,0
R_98_t4 \$98__t4 \$98 16.7641747213
* device instance _98 r0 *1 0,0
C_98 \$98 vsubs 7.92193e-16
* device instance _99_t0 r0 *1 0,0
R_99_t0 \$99__t0 \$99 14.0706287935
* device instance _99_t1 r0 *1 0,0
R_99_t1 \$99__t1 \$99 17.162141452
* device instance _99_t2 r0 *1 0,0
R_99_t2 \$99__t2 \$99 13.6875065396
* device instance _99_t3 r0 *1 0,0
R_99_t3 \$99__t3 \$99 9.52844849363
* device instance _99_t4 r0 *1 0,0
R_99_t4 \$99__t4 \$99 16.7641747213
* device instance _99 r0 *1 0,0
C_99 \$99 vsubs 7.92193e-16
* device instance BL0_t0 r0 *1 0,0
RBL0_t0 BL0__t0 BL0 1.62
* device instance BL0 r0 *1 0,0
CBL0 BL0 vsubs 4.98113e-16
* device instance BL1_t0 r0 *1 0,0
RBL1_t0 BL1__t0 BL1 1.62
* device instance BL1 r0 *1 0,0
CBL1 BL1 vsubs 4.98113e-16
* device instance BL10_t0 r0 *1 0,0
RBL10_t0 BL10__t0 BL10 1.62
* device instance BL10 r0 *1 0,0
CBL10 BL10 vsubs 4.98113e-16
* device instance BL100_t0 r0 *1 0,0
RBL100_t0 BL100__t0 BL100 1.62
* device instance BL100 r0 *1 0,0
CBL100 BL100 vsubs 4.98113e-16
* device instance BL101_t0 r0 *1 0,0
RBL101_t0 BL101__t0 BL101 1.62
* device instance BL101 r0 *1 0,0
CBL101 BL101 vsubs 4.98113e-16
* device instance BL102_t0 r0 *1 0,0
RBL102_t0 BL102__t0 BL102 1.62
* device instance BL102 r0 *1 0,0
CBL102 BL102 vsubs 4.98113e-16
* device instance BL103_t0 r0 *1 0,0
RBL103_t0 BL103__t0 BL103 1.62
* device instance BL103 r0 *1 0,0
CBL103 BL103 vsubs 4.98113e-16
* device instance BL104_t0 r0 *1 0,0
RBL104_t0 BL104__t0 BL104 1.62
* device instance BL104 r0 *1 0,0
CBL104 BL104 vsubs 4.98113e-16
* device instance BL105_t0 r0 *1 0,0
RBL105_t0 BL105__t0 BL105 1.62
* device instance BL105 r0 *1 0,0
CBL105 BL105 vsubs 4.98113e-16
* device instance BL106_t0 r0 *1 0,0
RBL106_t0 BL106__t0 BL106 1.62
* device instance BL106 r0 *1 0,0
CBL106 BL106 vsubs 4.98113e-16
* device instance BL107_t0 r0 *1 0,0
RBL107_t0 BL107__t0 BL107 1.62
* device instance BL107 r0 *1 0,0
CBL107 BL107 vsubs 4.98113e-16
* device instance BL108_t0 r0 *1 0,0
RBL108_t0 BL108__t0 BL108 1.62
* device instance BL108 r0 *1 0,0
CBL108 BL108 vsubs 4.98113e-16
* device instance BL109_t0 r0 *1 0,0
RBL109_t0 BL109__t0 BL109 1.62
* device instance BL109 r0 *1 0,0
CBL109 BL109 vsubs 4.98113e-16
* device instance BL11_t0 r0 *1 0,0
RBL11_t0 BL11__t0 BL11 1.62
* device instance BL11 r0 *1 0,0
CBL11 BL11 vsubs 4.98113e-16
* device instance BL110_t0 r0 *1 0,0
RBL110_t0 BL110__t0 BL110 1.62
* device instance BL110 r0 *1 0,0
CBL110 BL110 vsubs 4.98113e-16
* device instance BL111_t0 r0 *1 0,0
RBL111_t0 BL111__t0 BL111 1.62
* device instance BL111 r0 *1 0,0
CBL111 BL111 vsubs 4.98113e-16
* device instance BL112_t0 r0 *1 0,0
RBL112_t0 BL112__t0 BL112 1.62
* device instance BL112 r0 *1 0,0
CBL112 BL112 vsubs 4.98113e-16
* device instance BL113_t0 r0 *1 0,0
RBL113_t0 BL113__t0 BL113 1.62
* device instance BL113 r0 *1 0,0
CBL113 BL113 vsubs 4.98113e-16
* device instance BL114_t0 r0 *1 0,0
RBL114_t0 BL114__t0 BL114 1.62
* device instance BL114 r0 *1 0,0
CBL114 BL114 vsubs 4.98113e-16
* device instance BL115_t0 r0 *1 0,0
RBL115_t0 BL115__t0 BL115 1.62
* device instance BL115 r0 *1 0,0
CBL115 BL115 vsubs 4.98113e-16
* device instance BL116_t0 r0 *1 0,0
RBL116_t0 BL116__t0 BL116 1.62
* device instance BL116 r0 *1 0,0
CBL116 BL116 vsubs 4.98113e-16
* device instance BL117_t0 r0 *1 0,0
RBL117_t0 BL117__t0 BL117 1.62
* device instance BL117 r0 *1 0,0
CBL117 BL117 vsubs 4.98113e-16
* device instance BL118_t0 r0 *1 0,0
RBL118_t0 BL118__t0 BL118 1.62
* device instance BL118 r0 *1 0,0
CBL118 BL118 vsubs 4.98113e-16
* device instance BL119_t0 r0 *1 0,0
RBL119_t0 BL119__t0 BL119 1.62
* device instance BL119 r0 *1 0,0
CBL119 BL119 vsubs 4.98113e-16
* device instance BL12_t0 r0 *1 0,0
RBL12_t0 BL12__t0 BL12 1.62
* device instance BL12 r0 *1 0,0
CBL12 BL12 vsubs 4.98113e-16
* device instance BL120_t0 r0 *1 0,0
RBL120_t0 BL120__t0 BL120 1.62
* device instance BL120 r0 *1 0,0
CBL120 BL120 vsubs 4.98113e-16
* device instance BL121_t0 r0 *1 0,0
RBL121_t0 BL121__t0 BL121 1.62
* device instance BL121 r0 *1 0,0
CBL121 BL121 vsubs 4.98113e-16
* device instance BL122_t0 r0 *1 0,0
RBL122_t0 BL122__t0 BL122 1.62
* device instance BL122 r0 *1 0,0
CBL122 BL122 vsubs 4.98113e-16
* device instance BL123_t0 r0 *1 0,0
RBL123_t0 BL123__t0 BL123 1.62
* device instance BL123 r0 *1 0,0
CBL123 BL123 vsubs 4.98113e-16
* device instance BL124_t0 r0 *1 0,0
RBL124_t0 BL124__t0 BL124 1.62
* device instance BL124 r0 *1 0,0
CBL124 BL124 vsubs 4.98113e-16
* device instance BL125_t0 r0 *1 0,0
RBL125_t0 BL125__t0 BL125 1.62
* device instance BL125 r0 *1 0,0
CBL125 BL125 vsubs 4.98113e-16
* device instance BL126_t0 r0 *1 0,0
RBL126_t0 BL126__t0 BL126 1.62
* device instance BL126 r0 *1 0,0
CBL126 BL126 vsubs 4.98113e-16
* device instance BL127_t0 r0 *1 0,0
RBL127_t0 BL127__t0 BL127 1.62
* device instance BL127 r0 *1 0,0
CBL127 BL127 vsubs 4.98113e-16
* device instance BL13_t0 r0 *1 0,0
RBL13_t0 BL13__t0 BL13 1.62
* device instance BL13 r0 *1 0,0
CBL13 BL13 vsubs 4.98113e-16
* device instance BL14_t0 r0 *1 0,0
RBL14_t0 BL14__t0 BL14 1.62
* device instance BL14 r0 *1 0,0
CBL14 BL14 vsubs 4.98113e-16
* device instance BL15_t0 r0 *1 0,0
RBL15_t0 BL15__t0 BL15 1.62
* device instance BL15 r0 *1 0,0
CBL15 BL15 vsubs 4.98113e-16
* device instance BL16_t0 r0 *1 0,0
RBL16_t0 BL16__t0 BL16 1.62
* device instance BL16 r0 *1 0,0
CBL16 BL16 vsubs 4.98113e-16
* device instance BL17_t0 r0 *1 0,0
RBL17_t0 BL17__t0 BL17 1.62
* device instance BL17 r0 *1 0,0
CBL17 BL17 vsubs 4.98113e-16
* device instance BL18_t0 r0 *1 0,0
RBL18_t0 BL18__t0 BL18 1.62
* device instance BL18 r0 *1 0,0
CBL18 BL18 vsubs 4.98113e-16
* device instance BL19_t0 r0 *1 0,0
RBL19_t0 BL19__t0 BL19 1.62
* device instance BL19 r0 *1 0,0
CBL19 BL19 vsubs 4.98113e-16
* device instance BL2_t0 r0 *1 0,0
RBL2_t0 BL2__t0 BL2 1.62
* device instance BL2 r0 *1 0,0
CBL2 BL2 vsubs 4.98113e-16
* device instance BL20_t0 r0 *1 0,0
RBL20_t0 BL20__t0 BL20 1.62
* device instance BL20 r0 *1 0,0
CBL20 BL20 vsubs 4.98113e-16
* device instance BL21_t0 r0 *1 0,0
RBL21_t0 BL21__t0 BL21 1.62
* device instance BL21 r0 *1 0,0
CBL21 BL21 vsubs 4.98113e-16
* device instance BL22_t0 r0 *1 0,0
RBL22_t0 BL22__t0 BL22 1.62
* device instance BL22 r0 *1 0,0
CBL22 BL22 vsubs 4.98113e-16
* device instance BL23_t0 r0 *1 0,0
RBL23_t0 BL23__t0 BL23 1.62
* device instance BL23 r0 *1 0,0
CBL23 BL23 vsubs 4.98113e-16
* device instance BL24_t0 r0 *1 0,0
RBL24_t0 BL24__t0 BL24 1.62
* device instance BL24 r0 *1 0,0
CBL24 BL24 vsubs 4.98113e-16
* device instance BL25_t0 r0 *1 0,0
RBL25_t0 BL25__t0 BL25 1.62
* device instance BL25 r0 *1 0,0
CBL25 BL25 vsubs 4.98113e-16
* device instance BL26_t0 r0 *1 0,0
RBL26_t0 BL26__t0 BL26 1.62
* device instance BL26 r0 *1 0,0
CBL26 BL26 vsubs 4.98113e-16
* device instance BL27_t0 r0 *1 0,0
RBL27_t0 BL27__t0 BL27 1.62
* device instance BL27 r0 *1 0,0
CBL27 BL27 vsubs 4.98113e-16
* device instance BL28_t0 r0 *1 0,0
RBL28_t0 BL28__t0 BL28 1.62
* device instance BL28 r0 *1 0,0
CBL28 BL28 vsubs 4.98113e-16
* device instance BL29_t0 r0 *1 0,0
RBL29_t0 BL29__t0 BL29 1.62
* device instance BL29 r0 *1 0,0
CBL29 BL29 vsubs 4.98113e-16
* device instance BL3_t0 r0 *1 0,0
RBL3_t0 BL3__t0 BL3 1.62
* device instance BL3 r0 *1 0,0
CBL3 BL3 vsubs 4.98113e-16
* device instance BL30_t0 r0 *1 0,0
RBL30_t0 BL30__t0 BL30 1.62
* device instance BL30 r0 *1 0,0
CBL30 BL30 vsubs 4.98113e-16
* device instance BL31_t0 r0 *1 0,0
RBL31_t0 BL31__t0 BL31 1.62
* device instance BL31 r0 *1 0,0
CBL31 BL31 vsubs 4.98113e-16
* device instance BL32_t0 r0 *1 0,0
RBL32_t0 BL32__t0 BL32 1.62
* device instance BL32 r0 *1 0,0
CBL32 BL32 vsubs 4.98113e-16
* device instance BL33_t0 r0 *1 0,0
RBL33_t0 BL33__t0 BL33 1.62
* device instance BL33 r0 *1 0,0
CBL33 BL33 vsubs 4.98113e-16
* device instance BL34_t0 r0 *1 0,0
RBL34_t0 BL34__t0 BL34 1.62
* device instance BL34 r0 *1 0,0
CBL34 BL34 vsubs 4.98113e-16
* device instance BL35_t0 r0 *1 0,0
RBL35_t0 BL35__t0 BL35 1.62
* device instance BL35 r0 *1 0,0
CBL35 BL35 vsubs 4.98113e-16
* device instance BL36_t0 r0 *1 0,0
RBL36_t0 BL36__t0 BL36 1.62
* device instance BL36 r0 *1 0,0
CBL36 BL36 vsubs 4.98113e-16
* device instance BL37_t0 r0 *1 0,0
RBL37_t0 BL37__t0 BL37 1.62
* device instance BL37 r0 *1 0,0
CBL37 BL37 vsubs 4.98113e-16
* device instance BL38_t0 r0 *1 0,0
RBL38_t0 BL38__t0 BL38 1.62
* device instance BL38 r0 *1 0,0
CBL38 BL38 vsubs 4.98113e-16
* device instance BL39_t0 r0 *1 0,0
RBL39_t0 BL39__t0 BL39 1.62
* device instance BL39 r0 *1 0,0
CBL39 BL39 vsubs 4.98113e-16
* device instance BL4_t0 r0 *1 0,0
RBL4_t0 BL4__t0 BL4 1.62
* device instance BL4 r0 *1 0,0
CBL4 BL4 vsubs 4.98113e-16
* device instance BL40_t0 r0 *1 0,0
RBL40_t0 BL40__t0 BL40 1.62
* device instance BL40 r0 *1 0,0
CBL40 BL40 vsubs 4.98113e-16
* device instance BL41_t0 r0 *1 0,0
RBL41_t0 BL41__t0 BL41 1.62
* device instance BL41 r0 *1 0,0
CBL41 BL41 vsubs 4.98113e-16
* device instance BL42_t0 r0 *1 0,0
RBL42_t0 BL42__t0 BL42 1.62
* device instance BL42 r0 *1 0,0
CBL42 BL42 vsubs 4.98113e-16
* device instance BL43_t0 r0 *1 0,0
RBL43_t0 BL43__t0 BL43 1.62
* device instance BL43 r0 *1 0,0
CBL43 BL43 vsubs 4.98113e-16
* device instance BL44_t0 r0 *1 0,0
RBL44_t0 BL44__t0 BL44 1.62
* device instance BL44 r0 *1 0,0
CBL44 BL44 vsubs 4.98113e-16
* device instance BL45_t0 r0 *1 0,0
RBL45_t0 BL45__t0 BL45 1.62
* device instance BL45 r0 *1 0,0
CBL45 BL45 vsubs 4.98113e-16
* device instance BL46_t0 r0 *1 0,0
RBL46_t0 BL46__t0 BL46 1.62
* device instance BL46 r0 *1 0,0
CBL46 BL46 vsubs 4.98113e-16
* device instance BL47_t0 r0 *1 0,0
RBL47_t0 BL47__t0 BL47 1.62
* device instance BL47 r0 *1 0,0
CBL47 BL47 vsubs 4.98113e-16
* device instance BL48_t0 r0 *1 0,0
RBL48_t0 BL48__t0 BL48 1.62
* device instance BL48 r0 *1 0,0
CBL48 BL48 vsubs 4.98113e-16
* device instance BL49_t0 r0 *1 0,0
RBL49_t0 BL49__t0 BL49 1.62
* device instance BL49 r0 *1 0,0
CBL49 BL49 vsubs 4.98113e-16
* device instance BL5_t0 r0 *1 0,0
RBL5_t0 BL5__t0 BL5 1.62
* device instance BL5 r0 *1 0,0
CBL5 BL5 vsubs 4.98113e-16
* device instance BL50_t0 r0 *1 0,0
RBL50_t0 BL50__t0 BL50 1.62
* device instance BL50 r0 *1 0,0
CBL50 BL50 vsubs 4.98113e-16
* device instance BL51_t0 r0 *1 0,0
RBL51_t0 BL51__t0 BL51 1.62
* device instance BL51 r0 *1 0,0
CBL51 BL51 vsubs 4.98113e-16
* device instance BL52_t0 r0 *1 0,0
RBL52_t0 BL52__t0 BL52 1.62
* device instance BL52 r0 *1 0,0
CBL52 BL52 vsubs 4.98113e-16
* device instance BL53_t0 r0 *1 0,0
RBL53_t0 BL53__t0 BL53 1.62
* device instance BL53 r0 *1 0,0
CBL53 BL53 vsubs 4.98113e-16
* device instance BL54_t0 r0 *1 0,0
RBL54_t0 BL54__t0 BL54 1.62
* device instance BL54 r0 *1 0,0
CBL54 BL54 vsubs 4.98113e-16
* device instance BL55_t0 r0 *1 0,0
RBL55_t0 BL55__t0 BL55 1.62
* device instance BL55 r0 *1 0,0
CBL55 BL55 vsubs 4.98113e-16
* device instance BL56_t0 r0 *1 0,0
RBL56_t0 BL56__t0 BL56 1.62
* device instance BL56 r0 *1 0,0
CBL56 BL56 vsubs 4.98113e-16
* device instance BL57_t0 r0 *1 0,0
RBL57_t0 BL57__t0 BL57 1.62
* device instance BL57 r0 *1 0,0
CBL57 BL57 vsubs 4.98113e-16
* device instance BL58_t0 r0 *1 0,0
RBL58_t0 BL58__t0 BL58 1.62
* device instance BL58 r0 *1 0,0
CBL58 BL58 vsubs 4.98113e-16
* device instance BL59_t0 r0 *1 0,0
RBL59_t0 BL59__t0 BL59 1.62
* device instance BL59 r0 *1 0,0
CBL59 BL59 vsubs 4.98113e-16
* device instance BL6_t0 r0 *1 0,0
RBL6_t0 BL6__t0 BL6 1.62
* device instance BL6 r0 *1 0,0
CBL6 BL6 vsubs 4.98113e-16
* device instance BL60_t0 r0 *1 0,0
RBL60_t0 BL60__t0 BL60 1.62
* device instance BL60 r0 *1 0,0
CBL60 BL60 vsubs 4.98113e-16
* device instance BL61_t0 r0 *1 0,0
RBL61_t0 BL61__t0 BL61 1.62
* device instance BL61 r0 *1 0,0
CBL61 BL61 vsubs 4.98113e-16
* device instance BL62_t0 r0 *1 0,0
RBL62_t0 BL62__t0 BL62 1.62
* device instance BL62 r0 *1 0,0
CBL62 BL62 vsubs 4.98113e-16
* device instance BL63_t0 r0 *1 0,0
RBL63_t0 BL63__t0 BL63 1.62
* device instance BL63 r0 *1 0,0
CBL63 BL63 vsubs 4.98113e-16
* device instance BL64_t0 r0 *1 0,0
RBL64_t0 BL64__t0 BL64 1.62
* device instance BL64 r0 *1 0,0
CBL64 BL64 vsubs 4.98113e-16
* device instance BL65_t0 r0 *1 0,0
RBL65_t0 BL65__t0 BL65 1.62
* device instance BL65 r0 *1 0,0
CBL65 BL65 vsubs 4.98113e-16
* device instance BL66_t0 r0 *1 0,0
RBL66_t0 BL66__t0 BL66 1.62
* device instance BL66 r0 *1 0,0
CBL66 BL66 vsubs 4.98113e-16
* device instance BL67_t0 r0 *1 0,0
RBL67_t0 BL67__t0 BL67 1.62
* device instance BL67 r0 *1 0,0
CBL67 BL67 vsubs 4.98113e-16
* device instance BL68_t0 r0 *1 0,0
RBL68_t0 BL68__t0 BL68 1.62
* device instance BL68 r0 *1 0,0
CBL68 BL68 vsubs 4.98113e-16
* device instance BL69_t0 r0 *1 0,0
RBL69_t0 BL69__t0 BL69 1.62
* device instance BL69 r0 *1 0,0
CBL69 BL69 vsubs 4.98113e-16
* device instance BL7_t0 r0 *1 0,0
RBL7_t0 BL7__t0 BL7 1.62
* device instance BL7 r0 *1 0,0
CBL7 BL7 vsubs 4.98113e-16
* device instance BL70_t0 r0 *1 0,0
RBL70_t0 BL70__t0 BL70 1.62
* device instance BL70 r0 *1 0,0
CBL70 BL70 vsubs 4.98113e-16
* device instance BL71_t0 r0 *1 0,0
RBL71_t0 BL71__t0 BL71 1.62
* device instance BL71 r0 *1 0,0
CBL71 BL71 vsubs 4.98113e-16
* device instance BL72_t0 r0 *1 0,0
RBL72_t0 BL72__t0 BL72 1.62
* device instance BL72 r0 *1 0,0
CBL72 BL72 vsubs 4.98113e-16
* device instance BL73_t0 r0 *1 0,0
RBL73_t0 BL73__t0 BL73 1.62
* device instance BL73 r0 *1 0,0
CBL73 BL73 vsubs 4.98113e-16
* device instance BL74_t0 r0 *1 0,0
RBL74_t0 BL74__t0 BL74 1.62
* device instance BL74 r0 *1 0,0
CBL74 BL74 vsubs 4.98113e-16
* device instance BL75_t0 r0 *1 0,0
RBL75_t0 BL75__t0 BL75 1.62
* device instance BL75 r0 *1 0,0
CBL75 BL75 vsubs 4.98113e-16
* device instance BL76_t0 r0 *1 0,0
RBL76_t0 BL76__t0 BL76 1.62
* device instance BL76 r0 *1 0,0
CBL76 BL76 vsubs 4.98113e-16
* device instance BL77_t0 r0 *1 0,0
RBL77_t0 BL77__t0 BL77 1.62
* device instance BL77 r0 *1 0,0
CBL77 BL77 vsubs 4.98113e-16
* device instance BL78_t0 r0 *1 0,0
RBL78_t0 BL78__t0 BL78 1.62
* device instance BL78 r0 *1 0,0
CBL78 BL78 vsubs 4.98113e-16
* device instance BL79_t0 r0 *1 0,0
RBL79_t0 BL79__t0 BL79 1.62
* device instance BL79 r0 *1 0,0
CBL79 BL79 vsubs 4.98113e-16
* device instance BL8_t0 r0 *1 0,0
RBL8_t0 BL8__t0 BL8 1.62
* device instance BL8 r0 *1 0,0
CBL8 BL8 vsubs 4.98113e-16
* device instance BL80_t0 r0 *1 0,0
RBL80_t0 BL80__t0 BL80 1.62
* device instance BL80 r0 *1 0,0
CBL80 BL80 vsubs 4.98113e-16
* device instance BL81_t0 r0 *1 0,0
RBL81_t0 BL81__t0 BL81 1.62
* device instance BL81 r0 *1 0,0
CBL81 BL81 vsubs 4.98113e-16
* device instance BL82_t0 r0 *1 0,0
RBL82_t0 BL82__t0 BL82 1.62
* device instance BL82 r0 *1 0,0
CBL82 BL82 vsubs 4.98113e-16
* device instance BL83_t0 r0 *1 0,0
RBL83_t0 BL83__t0 BL83 1.62
* device instance BL83 r0 *1 0,0
CBL83 BL83 vsubs 4.98113e-16
* device instance BL84_t0 r0 *1 0,0
RBL84_t0 BL84__t0 BL84 1.62
* device instance BL84 r0 *1 0,0
CBL84 BL84 vsubs 4.98113e-16
* device instance BL85_t0 r0 *1 0,0
RBL85_t0 BL85__t0 BL85 1.62
* device instance BL85 r0 *1 0,0
CBL85 BL85 vsubs 4.98113e-16
* device instance BL86_t0 r0 *1 0,0
RBL86_t0 BL86__t0 BL86 1.62
* device instance BL86 r0 *1 0,0
CBL86 BL86 vsubs 4.98113e-16
* device instance BL87_t0 r0 *1 0,0
RBL87_t0 BL87__t0 BL87 1.62
* device instance BL87 r0 *1 0,0
CBL87 BL87 vsubs 4.98113e-16
* device instance BL88_t0 r0 *1 0,0
RBL88_t0 BL88__t0 BL88 1.62
* device instance BL88 r0 *1 0,0
CBL88 BL88 vsubs 4.98113e-16
* device instance BL89_t0 r0 *1 0,0
RBL89_t0 BL89__t0 BL89 1.62
* device instance BL89 r0 *1 0,0
CBL89 BL89 vsubs 4.98113e-16
* device instance BL9_t0 r0 *1 0,0
RBL9_t0 BL9__t0 BL9 1.62
* device instance BL9 r0 *1 0,0
CBL9 BL9 vsubs 4.98113e-16
* device instance BL90_t0 r0 *1 0,0
RBL90_t0 BL90__t0 BL90 1.62
* device instance BL90 r0 *1 0,0
CBL90 BL90 vsubs 4.98113e-16
* device instance BL91_t0 r0 *1 0,0
RBL91_t0 BL91__t0 BL91 1.62
* device instance BL91 r0 *1 0,0
CBL91 BL91 vsubs 4.98113e-16
* device instance BL92_t0 r0 *1 0,0
RBL92_t0 BL92__t0 BL92 1.62
* device instance BL92 r0 *1 0,0
CBL92 BL92 vsubs 4.98113e-16
* device instance BL93_t0 r0 *1 0,0
RBL93_t0 BL93__t0 BL93 1.62
* device instance BL93 r0 *1 0,0
CBL93 BL93 vsubs 4.98113e-16
* device instance BL94_t0 r0 *1 0,0
RBL94_t0 BL94__t0 BL94 1.62
* device instance BL94 r0 *1 0,0
CBL94 BL94 vsubs 4.98113e-16
* device instance BL95_t0 r0 *1 0,0
RBL95_t0 BL95__t0 BL95 1.62
* device instance BL95 r0 *1 0,0
CBL95 BL95 vsubs 4.98113e-16
* device instance BL96_t0 r0 *1 0,0
RBL96_t0 BL96__t0 BL96 1.62
* device instance BL96 r0 *1 0,0
CBL96 BL96 vsubs 4.98113e-16
* device instance BL97_t0 r0 *1 0,0
RBL97_t0 BL97__t0 BL97 1.62
* device instance BL97 r0 *1 0,0
CBL97 BL97 vsubs 4.98113e-16
* device instance BL98_t0 r0 *1 0,0
RBL98_t0 BL98__t0 BL98 1.62
* device instance BL98 r0 *1 0,0
CBL98 BL98 vsubs 4.98113e-16
* device instance BL99_t0 r0 *1 0,0
RBL99_t0 BL99__t0 BL99 1.62
* device instance BL99 r0 *1 0,0
CBL99 BL99 vsubs 4.98113e-16
* device instance BLB0_t0 r0 *1 0,0
RBLB0_t0 BLB0__t0 BLB0 1.62
* device instance BLB0 r0 *1 0,0
CBLB0 BLB0 vsubs 4.98113e-16
* device instance BLB1_t0 r0 *1 0,0
RBLB1_t0 BLB1__t0 BLB1 1.62
* device instance BLB1 r0 *1 0,0
CBLB1 BLB1 vsubs 4.98113e-16
* device instance BLB10_t0 r0 *1 0,0
RBLB10_t0 BLB10__t0 BLB10 1.62
* device instance BLB10 r0 *1 0,0
CBLB10 BLB10 vsubs 4.98113e-16
* device instance BLB100_t0 r0 *1 0,0
RBLB100_t0 BLB100__t0 BLB100 1.62
* device instance BLB100 r0 *1 0,0
CBLB100 BLB100 vsubs 4.98113e-16
* device instance BLB101_t0 r0 *1 0,0
RBLB101_t0 BLB101__t0 BLB101 1.62
* device instance BLB101 r0 *1 0,0
CBLB101 BLB101 vsubs 4.98113e-16
* device instance BLB102_t0 r0 *1 0,0
RBLB102_t0 BLB102__t0 BLB102 1.62
* device instance BLB102 r0 *1 0,0
CBLB102 BLB102 vsubs 4.98113e-16
* device instance BLB103_t0 r0 *1 0,0
RBLB103_t0 BLB103__t0 BLB103 1.62
* device instance BLB103 r0 *1 0,0
CBLB103 BLB103 vsubs 4.98113e-16
* device instance BLB104_t0 r0 *1 0,0
RBLB104_t0 BLB104__t0 BLB104 1.62
* device instance BLB104 r0 *1 0,0
CBLB104 BLB104 vsubs 4.98113e-16
* device instance BLB105_t0 r0 *1 0,0
RBLB105_t0 BLB105__t0 BLB105 1.62
* device instance BLB105 r0 *1 0,0
CBLB105 BLB105 vsubs 4.98113e-16
* device instance BLB106_t0 r0 *1 0,0
RBLB106_t0 BLB106__t0 BLB106 1.62
* device instance BLB106 r0 *1 0,0
CBLB106 BLB106 vsubs 4.98113e-16
* device instance BLB107_t0 r0 *1 0,0
RBLB107_t0 BLB107__t0 BLB107 1.62
* device instance BLB107 r0 *1 0,0
CBLB107 BLB107 vsubs 4.98113e-16
* device instance BLB108_t0 r0 *1 0,0
RBLB108_t0 BLB108__t0 BLB108 1.62
* device instance BLB108 r0 *1 0,0
CBLB108 BLB108 vsubs 4.98113e-16
* device instance BLB109_t0 r0 *1 0,0
RBLB109_t0 BLB109__t0 BLB109 1.62
* device instance BLB109 r0 *1 0,0
CBLB109 BLB109 vsubs 4.98113e-16
* device instance BLB11_t0 r0 *1 0,0
RBLB11_t0 BLB11__t0 BLB11 1.62
* device instance BLB11 r0 *1 0,0
CBLB11 BLB11 vsubs 4.98113e-16
* device instance BLB110_t0 r0 *1 0,0
RBLB110_t0 BLB110__t0 BLB110 1.62
* device instance BLB110 r0 *1 0,0
CBLB110 BLB110 vsubs 4.98113e-16
* device instance BLB111_t0 r0 *1 0,0
RBLB111_t0 BLB111__t0 BLB111 1.62
* device instance BLB111 r0 *1 0,0
CBLB111 BLB111 vsubs 4.98113e-16
* device instance BLB112_t0 r0 *1 0,0
RBLB112_t0 BLB112__t0 BLB112 1.62
* device instance BLB112 r0 *1 0,0
CBLB112 BLB112 vsubs 4.98113e-16
* device instance BLB113_t0 r0 *1 0,0
RBLB113_t0 BLB113__t0 BLB113 1.62
* device instance BLB113 r0 *1 0,0
CBLB113 BLB113 vsubs 4.98113e-16
* device instance BLB114_t0 r0 *1 0,0
RBLB114_t0 BLB114__t0 BLB114 1.62
* device instance BLB114 r0 *1 0,0
CBLB114 BLB114 vsubs 4.98113e-16
* device instance BLB115_t0 r0 *1 0,0
RBLB115_t0 BLB115__t0 BLB115 1.62
* device instance BLB115 r0 *1 0,0
CBLB115 BLB115 vsubs 4.98113e-16
* device instance BLB116_t0 r0 *1 0,0
RBLB116_t0 BLB116__t0 BLB116 1.62
* device instance BLB116 r0 *1 0,0
CBLB116 BLB116 vsubs 4.98113e-16
* device instance BLB117_t0 r0 *1 0,0
RBLB117_t0 BLB117__t0 BLB117 1.62
* device instance BLB117 r0 *1 0,0
CBLB117 BLB117 vsubs 4.98113e-16
* device instance BLB118_t0 r0 *1 0,0
RBLB118_t0 BLB118__t0 BLB118 1.62
* device instance BLB118 r0 *1 0,0
CBLB118 BLB118 vsubs 4.98113e-16
* device instance BLB119_t0 r0 *1 0,0
RBLB119_t0 BLB119__t0 BLB119 1.62
* device instance BLB119 r0 *1 0,0
CBLB119 BLB119 vsubs 4.98113e-16
* device instance BLB12_t0 r0 *1 0,0
RBLB12_t0 BLB12__t0 BLB12 1.62
* device instance BLB12 r0 *1 0,0
CBLB12 BLB12 vsubs 4.98113e-16
* device instance BLB120_t0 r0 *1 0,0
RBLB120_t0 BLB120__t0 BLB120 1.62
* device instance BLB120 r0 *1 0,0
CBLB120 BLB120 vsubs 4.98113e-16
* device instance BLB121_t0 r0 *1 0,0
RBLB121_t0 BLB121__t0 BLB121 1.62
* device instance BLB121 r0 *1 0,0
CBLB121 BLB121 vsubs 4.98113e-16
* device instance BLB122_t0 r0 *1 0,0
RBLB122_t0 BLB122__t0 BLB122 1.62
* device instance BLB122 r0 *1 0,0
CBLB122 BLB122 vsubs 4.98113e-16
* device instance BLB123_t0 r0 *1 0,0
RBLB123_t0 BLB123__t0 BLB123 1.62
* device instance BLB123 r0 *1 0,0
CBLB123 BLB123 vsubs 4.98113e-16
* device instance BLB124_t0 r0 *1 0,0
RBLB124_t0 BLB124__t0 BLB124 1.62
* device instance BLB124 r0 *1 0,0
CBLB124 BLB124 vsubs 4.98113e-16
* device instance BLB125_t0 r0 *1 0,0
RBLB125_t0 BLB125__t0 BLB125 1.62
* device instance BLB125 r0 *1 0,0
CBLB125 BLB125 vsubs 4.98113e-16
* device instance BLB126_t0 r0 *1 0,0
RBLB126_t0 BLB126__t0 BLB126 1.62
* device instance BLB126 r0 *1 0,0
CBLB126 BLB126 vsubs 4.98113e-16
* device instance BLB127_t0 r0 *1 0,0
RBLB127_t0 BLB127__t0 BLB127 1.62
* device instance BLB127 r0 *1 0,0
CBLB127 BLB127 vsubs 4.98113e-16
* device instance BLB13_t0 r0 *1 0,0
RBLB13_t0 BLB13__t0 BLB13 1.62
* device instance BLB13 r0 *1 0,0
CBLB13 BLB13 vsubs 4.98113e-16
* device instance BLB14_t0 r0 *1 0,0
RBLB14_t0 BLB14__t0 BLB14 1.62
* device instance BLB14 r0 *1 0,0
CBLB14 BLB14 vsubs 4.98113e-16
* device instance BLB15_t0 r0 *1 0,0
RBLB15_t0 BLB15__t0 BLB15 1.62
* device instance BLB15 r0 *1 0,0
CBLB15 BLB15 vsubs 4.98113e-16
* device instance BLB16_t0 r0 *1 0,0
RBLB16_t0 BLB16__t0 BLB16 1.62
* device instance BLB16 r0 *1 0,0
CBLB16 BLB16 vsubs 4.98113e-16
* device instance BLB17_t0 r0 *1 0,0
RBLB17_t0 BLB17__t0 BLB17 1.62
* device instance BLB17 r0 *1 0,0
CBLB17 BLB17 vsubs 4.98113e-16
* device instance BLB18_t0 r0 *1 0,0
RBLB18_t0 BLB18__t0 BLB18 1.62
* device instance BLB18 r0 *1 0,0
CBLB18 BLB18 vsubs 4.98113e-16
* device instance BLB19_t0 r0 *1 0,0
RBLB19_t0 BLB19__t0 BLB19 1.62
* device instance BLB19 r0 *1 0,0
CBLB19 BLB19 vsubs 4.98113e-16
* device instance BLB2_t0 r0 *1 0,0
RBLB2_t0 BLB2__t0 BLB2 1.62
* device instance BLB2 r0 *1 0,0
CBLB2 BLB2 vsubs 4.98113e-16
* device instance BLB20_t0 r0 *1 0,0
RBLB20_t0 BLB20__t0 BLB20 1.62
* device instance BLB20 r0 *1 0,0
CBLB20 BLB20 vsubs 4.98113e-16
* device instance BLB21_t0 r0 *1 0,0
RBLB21_t0 BLB21__t0 BLB21 1.62
* device instance BLB21 r0 *1 0,0
CBLB21 BLB21 vsubs 4.98113e-16
* device instance BLB22_t0 r0 *1 0,0
RBLB22_t0 BLB22__t0 BLB22 1.62
* device instance BLB22 r0 *1 0,0
CBLB22 BLB22 vsubs 4.98113e-16
* device instance BLB23_t0 r0 *1 0,0
RBLB23_t0 BLB23__t0 BLB23 1.62
* device instance BLB23 r0 *1 0,0
CBLB23 BLB23 vsubs 4.98113e-16
* device instance BLB24_t0 r0 *1 0,0
RBLB24_t0 BLB24__t0 BLB24 1.62
* device instance BLB24 r0 *1 0,0
CBLB24 BLB24 vsubs 4.98113e-16
* device instance BLB25_t0 r0 *1 0,0
RBLB25_t0 BLB25__t0 BLB25 1.62
* device instance BLB25 r0 *1 0,0
CBLB25 BLB25 vsubs 4.98113e-16
* device instance BLB26_t0 r0 *1 0,0
RBLB26_t0 BLB26__t0 BLB26 1.62
* device instance BLB26 r0 *1 0,0
CBLB26 BLB26 vsubs 4.98113e-16
* device instance BLB27_t0 r0 *1 0,0
RBLB27_t0 BLB27__t0 BLB27 1.62
* device instance BLB27 r0 *1 0,0
CBLB27 BLB27 vsubs 4.98113e-16
* device instance BLB28_t0 r0 *1 0,0
RBLB28_t0 BLB28__t0 BLB28 1.62
* device instance BLB28 r0 *1 0,0
CBLB28 BLB28 vsubs 4.98113e-16
* device instance BLB29_t0 r0 *1 0,0
RBLB29_t0 BLB29__t0 BLB29 1.62
* device instance BLB29 r0 *1 0,0
CBLB29 BLB29 vsubs 4.98113e-16
* device instance BLB3_t0 r0 *1 0,0
RBLB3_t0 BLB3__t0 BLB3 1.62
* device instance BLB3 r0 *1 0,0
CBLB3 BLB3 vsubs 4.98113e-16
* device instance BLB30_t0 r0 *1 0,0
RBLB30_t0 BLB30__t0 BLB30 1.62
* device instance BLB30 r0 *1 0,0
CBLB30 BLB30 vsubs 4.98113e-16
* device instance BLB31_t0 r0 *1 0,0
RBLB31_t0 BLB31__t0 BLB31 1.62
* device instance BLB31 r0 *1 0,0
CBLB31 BLB31 vsubs 4.98113e-16
* device instance BLB32_t0 r0 *1 0,0
RBLB32_t0 BLB32__t0 BLB32 1.62
* device instance BLB32 r0 *1 0,0
CBLB32 BLB32 vsubs 4.98113e-16
* device instance BLB33_t0 r0 *1 0,0
RBLB33_t0 BLB33__t0 BLB33 1.62
* device instance BLB33 r0 *1 0,0
CBLB33 BLB33 vsubs 4.98113e-16
* device instance BLB34_t0 r0 *1 0,0
RBLB34_t0 BLB34__t0 BLB34 1.62
* device instance BLB34 r0 *1 0,0
CBLB34 BLB34 vsubs 4.98113e-16
* device instance BLB35_t0 r0 *1 0,0
RBLB35_t0 BLB35__t0 BLB35 1.62
* device instance BLB35 r0 *1 0,0
CBLB35 BLB35 vsubs 4.98113e-16
* device instance BLB36_t0 r0 *1 0,0
RBLB36_t0 BLB36__t0 BLB36 1.62
* device instance BLB36 r0 *1 0,0
CBLB36 BLB36 vsubs 4.98113e-16
* device instance BLB37_t0 r0 *1 0,0
RBLB37_t0 BLB37__t0 BLB37 1.62
* device instance BLB37 r0 *1 0,0
CBLB37 BLB37 vsubs 4.98113e-16
* device instance BLB38_t0 r0 *1 0,0
RBLB38_t0 BLB38__t0 BLB38 1.62
* device instance BLB38 r0 *1 0,0
CBLB38 BLB38 vsubs 4.98113e-16
* device instance BLB39_t0 r0 *1 0,0
RBLB39_t0 BLB39__t0 BLB39 1.62
* device instance BLB39 r0 *1 0,0
CBLB39 BLB39 vsubs 4.98113e-16
* device instance BLB4_t0 r0 *1 0,0
RBLB4_t0 BLB4__t0 BLB4 1.62
* device instance BLB4 r0 *1 0,0
CBLB4 BLB4 vsubs 4.98113e-16
* device instance BLB40_t0 r0 *1 0,0
RBLB40_t0 BLB40__t0 BLB40 1.62
* device instance BLB40 r0 *1 0,0
CBLB40 BLB40 vsubs 4.98113e-16
* device instance BLB41_t0 r0 *1 0,0
RBLB41_t0 BLB41__t0 BLB41 1.62
* device instance BLB41 r0 *1 0,0
CBLB41 BLB41 vsubs 4.98113e-16
* device instance BLB42_t0 r0 *1 0,0
RBLB42_t0 BLB42__t0 BLB42 1.62
* device instance BLB42 r0 *1 0,0
CBLB42 BLB42 vsubs 4.98113e-16
* device instance BLB43_t0 r0 *1 0,0
RBLB43_t0 BLB43__t0 BLB43 1.62
* device instance BLB43 r0 *1 0,0
CBLB43 BLB43 vsubs 4.98113e-16
* device instance BLB44_t0 r0 *1 0,0
RBLB44_t0 BLB44__t0 BLB44 1.62
* device instance BLB44 r0 *1 0,0
CBLB44 BLB44 vsubs 4.98113e-16
* device instance BLB45_t0 r0 *1 0,0
RBLB45_t0 BLB45__t0 BLB45 1.62
* device instance BLB45 r0 *1 0,0
CBLB45 BLB45 vsubs 4.98113e-16
* device instance BLB46_t0 r0 *1 0,0
RBLB46_t0 BLB46__t0 BLB46 1.62
* device instance BLB46 r0 *1 0,0
CBLB46 BLB46 vsubs 4.98113e-16
* device instance BLB47_t0 r0 *1 0,0
RBLB47_t0 BLB47__t0 BLB47 1.62
* device instance BLB47 r0 *1 0,0
CBLB47 BLB47 vsubs 4.98113e-16
* device instance BLB48_t0 r0 *1 0,0
RBLB48_t0 BLB48__t0 BLB48 1.62
* device instance BLB48 r0 *1 0,0
CBLB48 BLB48 vsubs 4.98113e-16
* device instance BLB49_t0 r0 *1 0,0
RBLB49_t0 BLB49__t0 BLB49 1.62
* device instance BLB49 r0 *1 0,0
CBLB49 BLB49 vsubs 4.98113e-16
* device instance BLB5_t0 r0 *1 0,0
RBLB5_t0 BLB5__t0 BLB5 1.62
* device instance BLB5 r0 *1 0,0
CBLB5 BLB5 vsubs 4.98113e-16
* device instance BLB50_t0 r0 *1 0,0
RBLB50_t0 BLB50__t0 BLB50 1.62
* device instance BLB50 r0 *1 0,0
CBLB50 BLB50 vsubs 4.98113e-16
* device instance BLB51_t0 r0 *1 0,0
RBLB51_t0 BLB51__t0 BLB51 1.62
* device instance BLB51 r0 *1 0,0
CBLB51 BLB51 vsubs 4.98113e-16
* device instance BLB52_t0 r0 *1 0,0
RBLB52_t0 BLB52__t0 BLB52 1.62
* device instance BLB52 r0 *1 0,0
CBLB52 BLB52 vsubs 4.98113e-16
* device instance BLB53_t0 r0 *1 0,0
RBLB53_t0 BLB53__t0 BLB53 1.62
* device instance BLB53 r0 *1 0,0
CBLB53 BLB53 vsubs 4.98113e-16
* device instance BLB54_t0 r0 *1 0,0
RBLB54_t0 BLB54__t0 BLB54 1.62
* device instance BLB54 r0 *1 0,0
CBLB54 BLB54 vsubs 4.98113e-16
* device instance BLB55_t0 r0 *1 0,0
RBLB55_t0 BLB55__t0 BLB55 1.62
* device instance BLB55 r0 *1 0,0
CBLB55 BLB55 vsubs 4.98113e-16
* device instance BLB56_t0 r0 *1 0,0
RBLB56_t0 BLB56__t0 BLB56 1.62
* device instance BLB56 r0 *1 0,0
CBLB56 BLB56 vsubs 4.98113e-16
* device instance BLB57_t0 r0 *1 0,0
RBLB57_t0 BLB57__t0 BLB57 1.62
* device instance BLB57 r0 *1 0,0
CBLB57 BLB57 vsubs 4.98113e-16
* device instance BLB58_t0 r0 *1 0,0
RBLB58_t0 BLB58__t0 BLB58 1.62
* device instance BLB58 r0 *1 0,0
CBLB58 BLB58 vsubs 4.98113e-16
* device instance BLB59_t0 r0 *1 0,0
RBLB59_t0 BLB59__t0 BLB59 1.62
* device instance BLB59 r0 *1 0,0
CBLB59 BLB59 vsubs 4.98113e-16
* device instance BLB6_t0 r0 *1 0,0
RBLB6_t0 BLB6__t0 BLB6 1.62
* device instance BLB6 r0 *1 0,0
CBLB6 BLB6 vsubs 4.98113e-16
* device instance BLB60_t0 r0 *1 0,0
RBLB60_t0 BLB60__t0 BLB60 1.62
* device instance BLB60 r0 *1 0,0
CBLB60 BLB60 vsubs 4.98113e-16
* device instance BLB61_t0 r0 *1 0,0
RBLB61_t0 BLB61__t0 BLB61 1.62
* device instance BLB61 r0 *1 0,0
CBLB61 BLB61 vsubs 4.98113e-16
* device instance BLB62_t0 r0 *1 0,0
RBLB62_t0 BLB62__t0 BLB62 1.62
* device instance BLB62 r0 *1 0,0
CBLB62 BLB62 vsubs 4.98113e-16
* device instance BLB63_t0 r0 *1 0,0
RBLB63_t0 BLB63__t0 BLB63 1.62
* device instance BLB63 r0 *1 0,0
CBLB63 BLB63 vsubs 4.98113e-16
* device instance BLB64_t0 r0 *1 0,0
RBLB64_t0 BLB64__t0 BLB64 1.62
* device instance BLB64 r0 *1 0,0
CBLB64 BLB64 vsubs 4.98113e-16
* device instance BLB65_t0 r0 *1 0,0
RBLB65_t0 BLB65__t0 BLB65 1.62
* device instance BLB65 r0 *1 0,0
CBLB65 BLB65 vsubs 4.98113e-16
* device instance BLB66_t0 r0 *1 0,0
RBLB66_t0 BLB66__t0 BLB66 1.62
* device instance BLB66 r0 *1 0,0
CBLB66 BLB66 vsubs 4.98113e-16
* device instance BLB67_t0 r0 *1 0,0
RBLB67_t0 BLB67__t0 BLB67 1.62
* device instance BLB67 r0 *1 0,0
CBLB67 BLB67 vsubs 4.98113e-16
* device instance BLB68_t0 r0 *1 0,0
RBLB68_t0 BLB68__t0 BLB68 1.62
* device instance BLB68 r0 *1 0,0
CBLB68 BLB68 vsubs 4.98113e-16
* device instance BLB69_t0 r0 *1 0,0
RBLB69_t0 BLB69__t0 BLB69 1.62
* device instance BLB69 r0 *1 0,0
CBLB69 BLB69 vsubs 4.98113e-16
* device instance BLB7_t0 r0 *1 0,0
RBLB7_t0 BLB7__t0 BLB7 1.62
* device instance BLB7 r0 *1 0,0
CBLB7 BLB7 vsubs 4.98113e-16
* device instance BLB70_t0 r0 *1 0,0
RBLB70_t0 BLB70__t0 BLB70 1.62
* device instance BLB70 r0 *1 0,0
CBLB70 BLB70 vsubs 4.98113e-16
* device instance BLB71_t0 r0 *1 0,0
RBLB71_t0 BLB71__t0 BLB71 1.62
* device instance BLB71 r0 *1 0,0
CBLB71 BLB71 vsubs 4.98113e-16
* device instance BLB72_t0 r0 *1 0,0
RBLB72_t0 BLB72__t0 BLB72 1.62
* device instance BLB72 r0 *1 0,0
CBLB72 BLB72 vsubs 4.98113e-16
* device instance BLB73_t0 r0 *1 0,0
RBLB73_t0 BLB73__t0 BLB73 1.62
* device instance BLB73 r0 *1 0,0
CBLB73 BLB73 vsubs 4.98113e-16
* device instance BLB74_t0 r0 *1 0,0
RBLB74_t0 BLB74__t0 BLB74 1.62
* device instance BLB74 r0 *1 0,0
CBLB74 BLB74 vsubs 4.98113e-16
* device instance BLB75_t0 r0 *1 0,0
RBLB75_t0 BLB75__t0 BLB75 1.62
* device instance BLB75 r0 *1 0,0
CBLB75 BLB75 vsubs 4.98113e-16
* device instance BLB76_t0 r0 *1 0,0
RBLB76_t0 BLB76__t0 BLB76 1.62
* device instance BLB76 r0 *1 0,0
CBLB76 BLB76 vsubs 4.98113e-16
* device instance BLB77_t0 r0 *1 0,0
RBLB77_t0 BLB77__t0 BLB77 1.62
* device instance BLB77 r0 *1 0,0
CBLB77 BLB77 vsubs 4.98113e-16
* device instance BLB78_t0 r0 *1 0,0
RBLB78_t0 BLB78__t0 BLB78 1.62
* device instance BLB78 r0 *1 0,0
CBLB78 BLB78 vsubs 4.98113e-16
* device instance BLB79_t0 r0 *1 0,0
RBLB79_t0 BLB79__t0 BLB79 1.62
* device instance BLB79 r0 *1 0,0
CBLB79 BLB79 vsubs 4.98113e-16
* device instance BLB8_t0 r0 *1 0,0
RBLB8_t0 BLB8__t0 BLB8 1.62
* device instance BLB8 r0 *1 0,0
CBLB8 BLB8 vsubs 4.98113e-16
* device instance BLB80_t0 r0 *1 0,0
RBLB80_t0 BLB80__t0 BLB80 1.62
* device instance BLB80 r0 *1 0,0
CBLB80 BLB80 vsubs 4.98113e-16
* device instance BLB81_t0 r0 *1 0,0
RBLB81_t0 BLB81__t0 BLB81 1.62
* device instance BLB81 r0 *1 0,0
CBLB81 BLB81 vsubs 4.98113e-16
* device instance BLB82_t0 r0 *1 0,0
RBLB82_t0 BLB82__t0 BLB82 1.62
* device instance BLB82 r0 *1 0,0
CBLB82 BLB82 vsubs 4.98113e-16
* device instance BLB83_t0 r0 *1 0,0
RBLB83_t0 BLB83__t0 BLB83 1.62
* device instance BLB83 r0 *1 0,0
CBLB83 BLB83 vsubs 4.98113e-16
* device instance BLB84_t0 r0 *1 0,0
RBLB84_t0 BLB84__t0 BLB84 1.62
* device instance BLB84 r0 *1 0,0
CBLB84 BLB84 vsubs 4.98113e-16
* device instance BLB85_t0 r0 *1 0,0
RBLB85_t0 BLB85__t0 BLB85 1.62
* device instance BLB85 r0 *1 0,0
CBLB85 BLB85 vsubs 4.98113e-16
* device instance BLB86_t0 r0 *1 0,0
RBLB86_t0 BLB86__t0 BLB86 1.62
* device instance BLB86 r0 *1 0,0
CBLB86 BLB86 vsubs 4.98113e-16
* device instance BLB87_t0 r0 *1 0,0
RBLB87_t0 BLB87__t0 BLB87 1.62
* device instance BLB87 r0 *1 0,0
CBLB87 BLB87 vsubs 4.98113e-16
* device instance BLB88_t0 r0 *1 0,0
RBLB88_t0 BLB88__t0 BLB88 1.62
* device instance BLB88 r0 *1 0,0
CBLB88 BLB88 vsubs 4.98113e-16
* device instance BLB89_t0 r0 *1 0,0
RBLB89_t0 BLB89__t0 BLB89 1.62
* device instance BLB89 r0 *1 0,0
CBLB89 BLB89 vsubs 4.98113e-16
* device instance BLB9_t0 r0 *1 0,0
RBLB9_t0 BLB9__t0 BLB9 1.62
* device instance BLB9 r0 *1 0,0
CBLB9 BLB9 vsubs 4.98113e-16
* device instance BLB90_t0 r0 *1 0,0
RBLB90_t0 BLB90__t0 BLB90 1.62
* device instance BLB90 r0 *1 0,0
CBLB90 BLB90 vsubs 4.98113e-16
* device instance BLB91_t0 r0 *1 0,0
RBLB91_t0 BLB91__t0 BLB91 1.62
* device instance BLB91 r0 *1 0,0
CBLB91 BLB91 vsubs 4.98113e-16
* device instance BLB92_t0 r0 *1 0,0
RBLB92_t0 BLB92__t0 BLB92 1.62
* device instance BLB92 r0 *1 0,0
CBLB92 BLB92 vsubs 4.98113e-16
* device instance BLB93_t0 r0 *1 0,0
RBLB93_t0 BLB93__t0 BLB93 1.62
* device instance BLB93 r0 *1 0,0
CBLB93 BLB93 vsubs 4.98113e-16
* device instance BLB94_t0 r0 *1 0,0
RBLB94_t0 BLB94__t0 BLB94 1.62
* device instance BLB94 r0 *1 0,0
CBLB94 BLB94 vsubs 4.98113e-16
* device instance BLB95_t0 r0 *1 0,0
RBLB95_t0 BLB95__t0 BLB95 1.62
* device instance BLB95 r0 *1 0,0
CBLB95 BLB95 vsubs 4.98113e-16
* device instance BLB96_t0 r0 *1 0,0
RBLB96_t0 BLB96__t0 BLB96 1.62
* device instance BLB96 r0 *1 0,0
CBLB96 BLB96 vsubs 4.98113e-16
* device instance BLB97_t0 r0 *1 0,0
RBLB97_t0 BLB97__t0 BLB97 1.62
* device instance BLB97 r0 *1 0,0
CBLB97 BLB97 vsubs 4.98113e-16
* device instance BLB98_t0 r0 *1 0,0
RBLB98_t0 BLB98__t0 BLB98 1.62
* device instance BLB98 r0 *1 0,0
CBLB98 BLB98 vsubs 4.98113e-16
* device instance BLB99_t0 r0 *1 0,0
RBLB99_t0 BLB99__t0 BLB99 1.62
* device instance BLB99 r0 *1 0,0
CBLB99 BLB99 vsubs 4.98113e-16
* device instance VDD_t0 r0 *1 0,0
RVDD_t0 VDD__t0 VDD 1.51134682256
* device instance VDD_t1 r0 *1 0,0
RVDD_t1 VDD__t1 VDD 1.50506285762
* device instance VDD_t2 r0 *1 0,0
RVDD_t2 VDD__t2 VDD 0.816276395214
* device instance VDD_t3 r0 *1 0,0
RVDD_t3 VDD__t3 VDD 0.840027652539
* device instance VDD_t4 r0 *1 0,0
RVDD_t4 VDD__t4 VDD 0.650017593945
* device instance VDD_t5 r0 *1 0,0
RVDD_t5 VDD__t5 VDD 0.863778909863
* device instance VDD_t6 r0 *1 0,0
RVDD_t6 VDD__t6 VDD 0.887530167187
* device instance VDD_t7 r0 *1 0,0
RVDD_t7 VDD__t7 VDD 0.673768851269
* device instance VDD_t8 r0 *1 0,0
RVDD_t8 VDD__t8 VDD 0.911281424511
* device instance VDD_t9 r0 *1 0,0
RVDD_t9 VDD__t9 VDD 0.935032681835
* device instance VDD_t10 r0 *1 0,0
RVDD_t10 VDD__t10 VDD 1.44009305059
* device instance VDD_t11 r0 *1 0,0
RVDD_t11 VDD__t11 VDD 0.95878393916
* device instance VDD_t12 r0 *1 0,0
RVDD_t12 VDD__t12 VDD 0.982535196484
* device instance VDD_t13 r0 *1 0,0
RVDD_t13 VDD__t13 VDD 0.721271365918
* device instance VDD_t14 r0 *1 0,0
RVDD_t14 VDD__t14 VDD 1.00628645381
* device instance VDD_t15 r0 *1 0,0
RVDD_t15 VDD__t15 VDD 1.03003771113
* device instance VDD_t16 r0 *1 0,0
RVDD_t16 VDD__t16 VDD 0.745022623242
* device instance VDD_t17 r0 *1 0,0
RVDD_t17 VDD__t17 VDD 1.05378896846
* device instance VDD_t18 r0 *1 0,0
RVDD_t18 VDD__t18 VDD 1.07754022578
* device instance VDD_t19 r0 *1 0,0
RVDD_t19 VDD__t19 VDD 0.697520108593
* device instance VDD_t20 r0 *1 0,0
RVDD_t20 VDD__t20 VDD 0.483758792675
* device instance VDD_t21 r0 *1 0,0
RVDD_t21 VDD__t21 VDD 1.46384430791
* device instance VDD_t22 r0 *1 0,0
RVDD_t22 VDD__t22 VDD 1.48759556523
* device instance VDD_t23 r0 *1 0,0
RVDD_t23 VDD__t23 VDD 0.50751005
* device instance VDD_t24 r0 *1 0,0
RVDD_t24 VDD__t24 VDD 1.51134682256
* device instance VDD_t25 r0 *1 0,0
RVDD_t25 VDD__t25 VDD 0.151241190136
* device instance VDD_t26 r0 *1 0,0
RVDD_t26 VDD__t26 VDD 0.531261307324
* device instance VDD_t27 r0 *1 0,0
RVDD_t27 VDD__t27 VDD 0.17499244746
* device instance VDD_t28 r0 *1 0,0
RVDD_t28 VDD__t28 VDD 0.626266336621
* device instance VDD_t29 r0 *1 0,0
RVDD_t29 VDD__t29 VDD 0.222494962109
* device instance VDD_t30 r0 *1 0,0
RVDD_t30 VDD__t30 VDD 0.775057845508
* device instance VDD_t31 r0 *1 0,0
RVDD_t31 VDD__t31 VDD 0.578763821972
* device instance VDD_t32 r0 *1 0,0
RVDD_t32 VDD__t32 VDD 0.798809102832
* device instance VDD_t33 r0 *1 0,0
RVDD_t33 VDD__t33 VDD 0.822560360157
* device instance VDD_t34 r0 *1 0,0
RVDD_t34 VDD__t34 VDD 0.602515079296
* device instance VDD_t35 r0 *1 0,0
RVDD_t35 VDD__t35 VDD 0.846311617481
* device instance VDD_t36 r0 *1 0,0
RVDD_t36 VDD__t36 VDD 0.768773880566
* device instance VDD_t37 r0 *1 0,0
RVDD_t37 VDD__t37 VDD 0.79252513789
* device instance VDD_t38 r0 *1 0,0
RVDD_t38 VDD__t38 VDD 0.198743704785
* device instance VDD_t39 r0 *1 0,0
RVDD_t39 VDD__t39 VDD 0.656301558887
* device instance VDD_t40 r0 *1 0,0
RVDD_t40 VDD__t40 VDD 1.13132670537
* device instance VDD_t41 r0 *1 0,0
RVDD_t41 VDD__t41 VDD 0.246246219433
* device instance VDD_t42 r0 *1 0,0
RVDD_t42 VDD__t42 VDD 0.632550301563
* device instance VDD_t43 r0 *1 0,0
RVDD_t43 VDD__t43 VDD 0.269997476757
* device instance VDD_t44 r0 *1 0,0
RVDD_t44 VDD__t44 VDD 0.293748734082
* device instance VDD_t45 r0 *1 0,0
RVDD_t45 VDD__t45 VDD 0.608799044239
* device instance VDD_t46 r0 *1 0,0
RVDD_t46 VDD__t46 VDD 0.317499991406
* device instance VDD_t47 r0 *1 0,0
RVDD_t47 VDD__t47 VDD 1.10129148311
* device instance VDD_t48 r0 *1 0,0
RVDD_t48 VDD__t48 VDD 0.585047786915
* device instance VDD_t49 r0 *1 0,0
RVDD_t49 VDD__t49 VDD 0.418788985645
* device instance VDD_t50 r0 *1 0,0
RVDD_t50 VDD__t50 VDD 0.442540242969
* device instance VDD_t51 r0 *1 0,0
RVDD_t51 VDD__t51 VDD 0.56129652959
* device instance VDD_t52 r0 *1 0,0
RVDD_t52 VDD__t52 VDD 0.466291500293
* device instance VDD_t53 r0 *1 0,0
RVDD_t53 VDD__t53 VDD 0.490042757618
* device instance VDD_t54 r0 *1 0,0
RVDD_t54 VDD__t54 VDD 0.537545272266
* device instance VDD_t55 r0 *1 0,0
RVDD_t55 VDD__t55 VDD 0.513794014942
* device instance VDD_t56 r0 *1 0,0
RVDD_t56 VDD__t56 VDD 0.395037728321
* device instance VDD_t57 r0 *1 0,0
RVDD_t57 VDD__t57 VDD 0.365002506054
* device instance VDD_t58 r0 *1 0,0
RVDD_t58 VDD__t58 VDD 1.12504274043
* device instance VDD_t59 r0 *1 0,0
RVDD_t59 VDD__t59 VDD 0.34125124873
* device instance VDD_t60 r0 *1 0,0
RVDD_t60 VDD__t60 VDD 0.870062874805
* device instance VDD_t61 r0 *1 0,0
RVDD_t61 VDD__t61 VDD 0.436256278027
* device instance VDD_t62 r0 *1 0,0
RVDD_t62 VDD__t62 VDD 0.893814132129
* device instance VDD_t63 r0 *1 0,0
RVDD_t63 VDD__t63 VDD 0.917565389454
* device instance VDD_t64 r0 *1 0,0
RVDD_t64 VDD__t64 VDD 0.751306588184
* device instance VDD_t65 r0 *1 0,0
RVDD_t65 VDD__t65 VDD 1.10757544805
* device instance VDD_t66 r0 *1 0,0
RVDD_t66 VDD__t66 VDD 0.965067904102
* device instance VDD_t67 r0 *1 0,0
RVDD_t67 VDD__t67 VDD 0.72755533086
* device instance VDD_t68 r0 *1 0,0
RVDD_t68 VDD__t68 VDD 0.988819161426
* device instance VDD_t69 r0 *1 0,0
RVDD_t69 VDD__t69 VDD 1.01257041875
* device instance VDD_t70 r0 *1 0,0
RVDD_t70 VDD__t70 VDD 0.703804073536
* device instance VDD_t71 r0 *1 0,0
RVDD_t71 VDD__t71 VDD 1.03632167607
* device instance VDD_t72 r0 *1 0,0
RVDD_t72 VDD__t72 VDD 1.0600729334
* device instance VDD_t73 r0 *1 0,0
RVDD_t73 VDD__t73 VDD 0.680052816211
* device instance VDD_t74 r0 *1 0,0
RVDD_t74 VDD__t74 VDD 1.08382419072
* device instance VDD_t75 r0 *1 0,0
RVDD_t75 VDD__t75 VDD 0.941316646778
* device instance VDD_t76 r0 *1 0,0
RVDD_t76 VDD__t76 VDD 1.386306571
* device instance VDD_t77 r0 *1 0,0
RVDD_t77 VDD__t77 VDD 0.0799874181636
* device instance VDD_t78 r0 *1 0,0
RVDD_t78 VDD__t78 VDD 1.36255531367
* device instance VDD_t79 r0 *1 0,0
RVDD_t79 VDD__t79 VDD 1.29758550664
* device instance VDD_t80 r0 *1 0,0
RVDD_t80 VDD__t80 VDD 0.11002264043
* device instance VDD_t81 r0 *1 0,0
RVDD_t81 VDD__t81 VDD 1.33880405635
* device instance VDD_t82 r0 *1 0,0
RVDD_t82 VDD__t82 VDD 0.323783956348
* device instance VDD_t83 r0 *1 0,0
RVDD_t83 VDD__t83 VDD 0.103738675488
* device instance VDD_t84 r0 *1 0,0
RVDD_t84 VDD__t84 VDD 1.31505279902
* device instance VDD_t85 r0 *1 0,0
RVDD_t85 VDD__t85 VDD 0.133773897754
* device instance VDD_t86 r0 *1 0,0
RVDD_t86 VDD__t86 VDD 1.2913015417
* device instance VDD_t87 r0 *1 0,0
RVDD_t87 VDD__t87 VDD 0.2762814417
* device instance VDD_t88 r0 *1 0,0
RVDD_t88 VDD__t88 VDD 0.205027669727
* device instance VDD_t89 r0 *1 0,0
RVDD_t89 VDD__t89 VDD 1.26755028437
* device instance VDD_t90 r0 *1 0,0
RVDD_t90 VDD__t90 VDD 0.157525155079
* device instance VDD_t91 r0 *1 0,0
RVDD_t91 VDD__t91 VDD 0.127489932812
* device instance VDD_t92 r0 *1 0,0
RVDD_t92 VDD__t92 VDD 1.24379902705
* device instance VDD_t93 r0 *1 0,0
RVDD_t93 VDD__t93 VDD 0.300032699024
* device instance VDD_t94 r0 *1 0,0
RVDD_t94 VDD__t94 VDD 1.22004776973
* device instance VDD_t95 r0 *1 0,0
RVDD_t95 VDD__t95 VDD 1.1550779627
* device instance VDD_t96 r0 *1 0,0
RVDD_t96 VDD__t96 VDD 0.181276412403
* device instance VDD_t97 r0 *1 0,0
RVDD_t97 VDD__t97 VDD 0.555012564648
* device instance VDD_t98 r0 *1 0,0
RVDD_t98 VDD__t98 VDD 1.1962965124
* device instance VDD_t99 r0 *1 0,0
RVDD_t99 VDD__t99 VDD 1.32133676397
* device instance VDD_t100 r0 *1 0,0
RVDD_t100 VDD__t100 VDD 1.17254525508
* device instance VDD_t101 r0 *1 0,0
RVDD_t101 VDD__t101 VDD 1.14879399775
* device instance VDD_t102 r0 *1 0,0
RVDD_t102 VDD__t102 VDD 1.17882922002
* device instance VDD_t103 r0 *1 0,0
RVDD_t103 VDD__t103 VDD 1.22633173467
* device instance VDD_t104 r0 *1 0,0
RVDD_t104 VDD__t104 VDD 1.41634179326
* device instance VDD_t105 r0 *1 0,0
RVDD_t105 VDD__t105 VDD 0.412505020703
* device instance VDD_t106 r0 *1 0,0
RVDD_t106 VDD__t106 VDD 0.460007535351
* device instance VDD_t107 r0 *1 0,0
RVDD_t107 VDD__t107 VDD 1.39259053594
* device instance VDD_t108 r0 *1 0,0
RVDD_t108 VDD__t108 VDD 0.252530184375
* device instance VDD_t109 r0 *1 0,0
RVDD_t109 VDD__t109 VDD 1.25008299199
* device instance VDD_t110 r0 *1 0,0
RVDD_t110 VDD__t110 VDD 1.36883927861
* device instance VDD_t111 r0 *1 0,0
RVDD_t111 VDD__t111 VDD 0.388753763378
* device instance VDD_t112 r0 *1 0,0
RVDD_t112 VDD__t112 VDD 1.34508802129
* device instance VDD_t113 r0 *1 0,0
RVDD_t113 VDD__t113 VDD 0.371286470997
* device instance VDD_t114 r0 *1 0,0
RVDD_t114 VDD__t114 VDD 0.0150176111333
* device instance VDD_t115 r0 *1 0,0
RVDD_t115 VDD__t115 VDD 0.00873364619097
* device instance VDD_t116 r0 *1 0,0
RVDD_t116 VDD__t116 VDD 0.228778927051
* device instance VDD_t117 r0 *1 0,0
RVDD_t117 VDD__t117 VDD 0.0387688684575
* device instance VDD_t118 r0 *1 0,0
RVDD_t118 VDD__t118 VDD 1.48131160029
* device instance VDD_t119 r0 *1 0,0
RVDD_t119 VDD__t119 VDD 0.0324849035152
* device instance VDD_t120 r0 *1 0,0
RVDD_t120 VDD__t120 VDD 0.347535213672
* device instance VDD_t121 r0 *1 0,0
RVDD_t121 VDD__t121 VDD 1.45756034297
* device instance VDD_t122 r0 *1 0,0
RVDD_t122 VDD__t122 VDD 0.0625201257817
* device instance VDD_t123 r0 *1 0,0
RVDD_t123 VDD__t123 VDD 1.43380908564
* device instance VDD_t124 r0 *1 0,0
RVDD_t124 VDD__t124 VDD 1.27383424932
* device instance VDD_t125 r0 *1 0,0
RVDD_t125 VDD__t125 VDD 0.0562361608394
* device instance VDD_t126 r0 *1 0,0
RVDD_t126 VDD__t126 VDD 1.41005782832
* device instance VDD_t127 r0 *1 0,0
RVDD_t127 VDD__t127 VDD 0.0862713831059
* device instance VDD_t128 r0 *1 0,0
RVDD_t128 VDD__t128 VDD 1.20258047734
* device instance VDD_t129 r0 *1 0,0
RVDD_t129 VDD__t129 VDD 0.697520108593
* device instance VDD_t130 r0 *1 0,0
RVDD_t130 VDD__t130 VDD 0.293748734082
* device instance VDD_t131 r0 *1 0,0
RVDD_t131 VDD__t131 VDD 0.673768851269
* device instance VDD_t132 r0 *1 0,0
RVDD_t132 VDD__t132 VDD 0.650017593945
* device instance VDD_t133 r0 *1 0,0
RVDD_t133 VDD__t133 VDD 0.317499991406
* device instance VDD_t134 r0 *1 0,0
RVDD_t134 VDD__t134 VDD 0.626266336621
* device instance VDD_t135 r0 *1 0,0
RVDD_t135 VDD__t135 VDD 0.34125124873
* device instance VDD_t136 r0 *1 0,0
RVDD_t136 VDD__t136 VDD 0.602515079296
* device instance VDD_t137 r0 *1 0,0
RVDD_t137 VDD__t137 VDD 0.365002506054
* device instance VDD_t138 r0 *1 0,0
RVDD_t138 VDD__t138 VDD 0.578763821972
* device instance VDD_t139 r0 *1 0,0
RVDD_t139 VDD__t139 VDD 0.555012564648
* device instance VDD_t140 r0 *1 0,0
RVDD_t140 VDD__t140 VDD 0.395037728321
* device instance VDD_t141 r0 *1 0,0
RVDD_t141 VDD__t141 VDD 0.418788985645
* device instance VDD_t142 r0 *1 0,0
RVDD_t142 VDD__t142 VDD 0.269997476757
* device instance VDD_t143 r0 *1 0,0
RVDD_t143 VDD__t143 VDD 0.466291500293
* device instance VDD_t144 r0 *1 0,0
RVDD_t144 VDD__t144 VDD 0.490042757618
* device instance VDD_t145 r0 *1 0,0
RVDD_t145 VDD__t145 VDD 0.442540242969
* device instance VDD_t146 r0 *1 0,0
RVDD_t146 VDD__t146 VDD 0.513794014942
* device instance VDD_t147 r0 *1 0,0
RVDD_t147 VDD__t147 VDD 0.00873364619097
* device instance VDD_t148 r0 *1 0,0
RVDD_t148 VDD__t148 VDD 0.537545272266
* device instance VDD_t149 r0 *1 0,0
RVDD_t149 VDD__t149 VDD 0.531261307324
* device instance VDD_t150 r0 *1 0,0
RVDD_t150 VDD__t150 VDD 0.0324849035152
* device instance VDD_t151 r0 *1 0,0
RVDD_t151 VDD__t151 VDD 0.56129652959
* device instance VDD_t152 r0 *1 0,0
RVDD_t152 VDD__t152 VDD 0.585047786915
* device instance VDD_t153 r0 *1 0,0
RVDD_t153 VDD__t153 VDD 0.0562361608394
* device instance VDD_t154 r0 *1 0,0
RVDD_t154 VDD__t154 VDD 0.608799044239
* device instance VDD_t155 r0 *1 0,0
RVDD_t155 VDD__t155 VDD 0.0799874181636
* device instance VDD_t156 r0 *1 0,0
RVDD_t156 VDD__t156 VDD 0.632550301563
* device instance VDD_t157 r0 *1 0,0
RVDD_t157 VDD__t157 VDD 0.371286470997
* device instance VDD_t158 r0 *1 0,0
RVDD_t158 VDD__t158 VDD 0.656301558887
* device instance VDD_t159 r0 *1 0,0
RVDD_t159 VDD__t159 VDD 0.127489932812
* device instance VDD_t160 r0 *1 0,0
RVDD_t160 VDD__t160 VDD 0.680052816211
* device instance VDD_t161 r0 *1 0,0
RVDD_t161 VDD__t161 VDD 0.703804073536
* device instance VDD_t162 r0 *1 0,0
RVDD_t162 VDD__t162 VDD 0.151241190136
* device instance VDD_t163 r0 *1 0,0
RVDD_t163 VDD__t163 VDD 0.72755533086
* device instance VDD_t164 r0 *1 0,0
RVDD_t164 VDD__t164 VDD 0.17499244746
* device instance VDD_t165 r0 *1 0,0
RVDD_t165 VDD__t165 VDD 0.751306588184
* device instance VDD_t166 r0 *1 0,0
RVDD_t166 VDD__t166 VDD 0.198743704785
* device instance VDD_t167 r0 *1 0,0
RVDD_t167 VDD__t167 VDD 0.347535213672
* device instance VDD_t168 r0 *1 0,0
RVDD_t168 VDD__t168 VDD 0.222494962109
* device instance VDD_t169 r0 *1 0,0
RVDD_t169 VDD__t169 VDD 0.323783956348
* device instance VDD_t170 r0 *1 0,0
RVDD_t170 VDD__t170 VDD 0.745022623242
* device instance VDD_t171 r0 *1 0,0
RVDD_t171 VDD__t171 VDD 0.246246219433
* device instance VDD_t172 r0 *1 0,0
RVDD_t172 VDD__t172 VDD 0.721271365918
* device instance VDD_t173 r0 *1 0,0
RVDD_t173 VDD__t173 VDD 0.103738675488
* device instance VDD_t174 r0 *1 0,0
RVDD_t174 VDD__t174 VDD 1.34508802129
* device instance VDD_t175 r0 *1 0,0
RVDD_t175 VDD__t175 VDD 1.36883927861
* device instance VDD_t176 r0 *1 0,0
RVDD_t176 VDD__t176 VDD 1.39259053594
* device instance VDD_t177 r0 *1 0,0
RVDD_t177 VDD__t177 VDD 1.41634179326
* device instance VDD_t178 r0 *1 0,0
RVDD_t178 VDD__t178 VDD 1.44009305059
* device instance VDD_t179 r0 *1 0,0
RVDD_t179 VDD__t179 VDD 1.46384430791
* device instance VDD_t180 r0 *1 0,0
RVDD_t180 VDD__t180 VDD 1.48759556523
* device instance VDD_t181 r0 *1 0,0
RVDD_t181 VDD__t181 VDD 1.33880405635
* device instance VDD_t182 r0 *1 0,0
RVDD_t182 VDD__t182 VDD 0.205027669727
* device instance VDD_t183 r0 *1 0,0
RVDD_t183 VDD__t183 VDD 1.386306571
* device instance VDD_t184 r0 *1 0,0
RVDD_t184 VDD__t184 VDD 1.41005782832
* device instance VDD_t185 r0 *1 0,0
RVDD_t185 VDD__t185 VDD 1.43380908564
* device instance VDD_t186 r0 *1 0,0
RVDD_t186 VDD__t186 VDD 1.45756034297
* device instance VDD_t187 r0 *1 0,0
RVDD_t187 VDD__t187 VDD 1.48131160029
* device instance VDD_t188 r0 *1 0,0
RVDD_t188 VDD__t188 VDD 1.50506285762
* device instance VDD_t189 r0 *1 0,0
RVDD_t189 VDD__t189 VDD 0.133773897754
* device instance VDD_t190 r0 *1 0,0
RVDD_t190 VDD__t190 VDD 0.157525155079
* device instance VDD_t191 r0 *1 0,0
RVDD_t191 VDD__t191 VDD 0.181276412403
* device instance VDD_t192 r0 *1 0,0
RVDD_t192 VDD__t192 VDD 1.36255531367
* device instance VDD_t193 r0 *1 0,0
RVDD_t193 VDD__t193 VDD 0.0150176111333
* device instance VDD_t194 r0 *1 0,0
RVDD_t194 VDD__t194 VDD 0.0387688684575
* device instance VDD_t195 r0 *1 0,0
RVDD_t195 VDD__t195 VDD 0.0625201257817
* device instance VDD_t196 r0 *1 0,0
RVDD_t196 VDD__t196 VDD 0.0862713831059
* device instance VDD_t197 r0 *1 0,0
RVDD_t197 VDD__t197 VDD 0.11002264043
* device instance VDD_t198 r0 *1 0,0
RVDD_t198 VDD__t198 VDD 1.14879399775
* device instance VDD_t199 r0 *1 0,0
RVDD_t199 VDD__t199 VDD 1.17254525508
* device instance VDD_t200 r0 *1 0,0
RVDD_t200 VDD__t200 VDD 1.1962965124
* device instance VDD_t201 r0 *1 0,0
RVDD_t201 VDD__t201 VDD 1.22004776973
* device instance VDD_t202 r0 *1 0,0
RVDD_t202 VDD__t202 VDD 1.32133676397
* device instance VDD_t203 r0 *1 0,0
RVDD_t203 VDD__t203 VDD 1.26755028437
* device instance VDD_t204 r0 *1 0,0
RVDD_t204 VDD__t204 VDD 1.2913015417
* device instance VDD_t205 r0 *1 0,0
RVDD_t205 VDD__t205 VDD 1.31505279902
* device instance VDD_t206 r0 *1 0,0
RVDD_t206 VDD__t206 VDD 1.1550779627
* device instance VDD_t207 r0 *1 0,0
RVDD_t207 VDD__t207 VDD 1.17882922002
* device instance VDD_t208 r0 *1 0,0
RVDD_t208 VDD__t208 VDD 1.20258047734
* device instance VDD_t209 r0 *1 0,0
RVDD_t209 VDD__t209 VDD 1.22633173467
* device instance VDD_t210 r0 *1 0,0
RVDD_t210 VDD__t210 VDD 1.25008299199
* device instance VDD_t211 r0 *1 0,0
RVDD_t211 VDD__t211 VDD 1.27383424932
* device instance VDD_t212 r0 *1 0,0
RVDD_t212 VDD__t212 VDD 1.29758550664
* device instance VDD_t213 r0 *1 0,0
RVDD_t213 VDD__t213 VDD 1.24379902705
* device instance VDD_t214 r0 *1 0,0
RVDD_t214 VDD__t214 VDD 0.911281424511
* device instance VDD_t215 r0 *1 0,0
RVDD_t215 VDD__t215 VDD 0.935032681835
* device instance VDD_t216 r0 *1 0,0
RVDD_t216 VDD__t216 VDD 0.95878393916
* device instance VDD_t217 r0 *1 0,0
RVDD_t217 VDD__t217 VDD 0.982535196484
* device instance VDD_t218 r0 *1 0,0
RVDD_t218 VDD__t218 VDD 1.00628645381
* device instance VDD_t219 r0 *1 0,0
RVDD_t219 VDD__t219 VDD 1.03003771113
* device instance VDD_t220 r0 *1 0,0
RVDD_t220 VDD__t220 VDD 1.05378896846
* device instance VDD_t221 r0 *1 0,0
RVDD_t221 VDD__t221 VDD 1.07754022578
* device instance VDD_t222 r0 *1 0,0
RVDD_t222 VDD__t222 VDD 1.10129148311
* device instance VDD_t223 r0 *1 0,0
RVDD_t223 VDD__t223 VDD 0.863778909863
* device instance VDD_t224 r0 *1 0,0
RVDD_t224 VDD__t224 VDD 0.228778927051
* device instance VDD_t225 r0 *1 0,0
RVDD_t225 VDD__t225 VDD 0.252530184375
* device instance VDD_t226 r0 *1 0,0
RVDD_t226 VDD__t226 VDD 0.2762814417
* device instance VDD_t227 r0 *1 0,0
RVDD_t227 VDD__t227 VDD 0.300032699024
* device instance VDD_t228 r0 *1 0,0
RVDD_t228 VDD__t228 VDD 0.388753763378
* device instance VDD_t229 r0 *1 0,0
RVDD_t229 VDD__t229 VDD 0.412505020703
* device instance VDD_t230 r0 *1 0,0
RVDD_t230 VDD__t230 VDD 0.436256278027
* device instance VDD_t231 r0 *1 0,0
RVDD_t231 VDD__t231 VDD 0.460007535351
* device instance VDD_t232 r0 *1 0,0
RVDD_t232 VDD__t232 VDD 0.483758792675
* device instance VDD_t233 r0 *1 0,0
RVDD_t233 VDD__t233 VDD 0.887530167187
* device instance VDD_t234 r0 *1 0,0
RVDD_t234 VDD__t234 VDD 1.12504274043
* device instance VDD_t235 r0 *1 0,0
RVDD_t235 VDD__t235 VDD 0.50751005
* device instance VDD_t236 r0 *1 0,0
RVDD_t236 VDD__t236 VDD 0.79252513789
* device instance VDD_t237 r0 *1 0,0
RVDD_t237 VDD__t237 VDD 0.816276395214
* device instance VDD_t238 r0 *1 0,0
RVDD_t238 VDD__t238 VDD 0.840027652539
* device instance VDD_t239 r0 *1 0,0
RVDD_t239 VDD__t239 VDD 0.775057845508
* device instance VDD_t240 r0 *1 0,0
RVDD_t240 VDD__t240 VDD 0.798809102832
* device instance VDD_t241 r0 *1 0,0
RVDD_t241 VDD__t241 VDD 0.822560360157
* device instance VDD_t242 r0 *1 0,0
RVDD_t242 VDD__t242 VDD 0.846311617481
* device instance VDD_t243 r0 *1 0,0
RVDD_t243 VDD__t243 VDD 0.870062874805
* device instance VDD_t244 r0 *1 0,0
RVDD_t244 VDD__t244 VDD 0.893814132129
* device instance VDD_t245 r0 *1 0,0
RVDD_t245 VDD__t245 VDD 0.917565389454
* device instance VDD_t246 r0 *1 0,0
RVDD_t246 VDD__t246 VDD 0.941316646778
* device instance VDD_t247 r0 *1 0,0
RVDD_t247 VDD__t247 VDD 0.965067904102
* device instance VDD_t248 r0 *1 0,0
RVDD_t248 VDD__t248 VDD 0.988819161426
* device instance VDD_t249 r0 *1 0,0
RVDD_t249 VDD__t249 VDD 1.01257041875
* device instance VDD_t250 r0 *1 0,0
RVDD_t250 VDD__t250 VDD 1.03632167607
* device instance VDD_t251 r0 *1 0,0
RVDD_t251 VDD__t251 VDD 1.0600729334
* device instance VDD_t252 r0 *1 0,0
RVDD_t252 VDD__t252 VDD 1.08382419072
* device instance VDD_t253 r0 *1 0,0
RVDD_t253 VDD__t253 VDD 1.10757544805
* device instance VDD_t254 r0 *1 0,0
RVDD_t254 VDD__t254 VDD 0.768773880566
* device instance VDD_t255 r0 *1 0,0
RVDD_t255 VDD__t255 VDD 1.13132670537
* device instance VDD_t256 r0 *1 0,0
RVDD_t256 VDD__t256 VDD 1.50506285762
* device instance VDD_t257 r0 *1 0,0
RVDD_t257 VDD__t257 VDD 1.51134682256
* device instance VDD_t258 r0 *1 0,0
RVDD_t258 VDD__t258 VDD 0.697520108593
* device instance VDD_t259 r0 *1 0,0
RVDD_t259 VDD__t259 VDD 0.293748734082
* device instance VDD_t260 r0 *1 0,0
RVDD_t260 VDD__t260 VDD 0.673768851269
* device instance VDD_t261 r0 *1 0,0
RVDD_t261 VDD__t261 VDD 0.650017593945
* device instance VDD_t262 r0 *1 0,0
RVDD_t262 VDD__t262 VDD 0.317499991406
* device instance VDD_t263 r0 *1 0,0
RVDD_t263 VDD__t263 VDD 0.626266336621
* device instance VDD_t264 r0 *1 0,0
RVDD_t264 VDD__t264 VDD 0.34125124873
* device instance VDD_t265 r0 *1 0,0
RVDD_t265 VDD__t265 VDD 0.602515079296
* device instance VDD_t266 r0 *1 0,0
RVDD_t266 VDD__t266 VDD 0.365002506054
* device instance VDD_t267 r0 *1 0,0
RVDD_t267 VDD__t267 VDD 0.578763821972
* device instance VDD_t268 r0 *1 0,0
RVDD_t268 VDD__t268 VDD 0.555012564648
* device instance VDD_t269 r0 *1 0,0
RVDD_t269 VDD__t269 VDD 0.395037728321
* device instance VDD_t270 r0 *1 0,0
RVDD_t270 VDD__t270 VDD 0.418788985645
* device instance VDD_t271 r0 *1 0,0
RVDD_t271 VDD__t271 VDD 0.269997476757
* device instance VDD_t272 r0 *1 0,0
RVDD_t272 VDD__t272 VDD 0.466291500293
* device instance VDD_t273 r0 *1 0,0
RVDD_t273 VDD__t273 VDD 0.490042757618
* device instance VDD_t274 r0 *1 0,0
RVDD_t274 VDD__t274 VDD 0.442540242969
* device instance VDD_t275 r0 *1 0,0
RVDD_t275 VDD__t275 VDD 0.513794014942
* device instance VDD_t276 r0 *1 0,0
RVDD_t276 VDD__t276 VDD 0.00873364619097
* device instance VDD_t277 r0 *1 0,0
RVDD_t277 VDD__t277 VDD 0.537545272266
* device instance VDD_t278 r0 *1 0,0
RVDD_t278 VDD__t278 VDD 0.531261307324
* device instance VDD_t279 r0 *1 0,0
RVDD_t279 VDD__t279 VDD 0.0324849035152
* device instance VDD_t280 r0 *1 0,0
RVDD_t280 VDD__t280 VDD 0.56129652959
* device instance VDD_t281 r0 *1 0,0
RVDD_t281 VDD__t281 VDD 0.585047786915
* device instance VDD_t282 r0 *1 0,0
RVDD_t282 VDD__t282 VDD 0.0562361608394
* device instance VDD_t283 r0 *1 0,0
RVDD_t283 VDD__t283 VDD 0.608799044239
* device instance VDD_t284 r0 *1 0,0
RVDD_t284 VDD__t284 VDD 0.0799874181636
* device instance VDD_t285 r0 *1 0,0
RVDD_t285 VDD__t285 VDD 0.632550301563
* device instance VDD_t286 r0 *1 0,0
RVDD_t286 VDD__t286 VDD 0.371286470997
* device instance VDD_t287 r0 *1 0,0
RVDD_t287 VDD__t287 VDD 0.656301558887
* device instance VDD_t288 r0 *1 0,0
RVDD_t288 VDD__t288 VDD 0.127489932812
* device instance VDD_t289 r0 *1 0,0
RVDD_t289 VDD__t289 VDD 0.680052816211
* device instance VDD_t290 r0 *1 0,0
RVDD_t290 VDD__t290 VDD 0.703804073536
* device instance VDD_t291 r0 *1 0,0
RVDD_t291 VDD__t291 VDD 0.151241190136
* device instance VDD_t292 r0 *1 0,0
RVDD_t292 VDD__t292 VDD 0.72755533086
* device instance VDD_t293 r0 *1 0,0
RVDD_t293 VDD__t293 VDD 0.17499244746
* device instance VDD_t294 r0 *1 0,0
RVDD_t294 VDD__t294 VDD 0.751306588184
* device instance VDD_t295 r0 *1 0,0
RVDD_t295 VDD__t295 VDD 0.198743704785
* device instance VDD_t296 r0 *1 0,0
RVDD_t296 VDD__t296 VDD 0.347535213672
* device instance VDD_t297 r0 *1 0,0
RVDD_t297 VDD__t297 VDD 0.222494962109
* device instance VDD_t298 r0 *1 0,0
RVDD_t298 VDD__t298 VDD 0.323783956348
* device instance VDD_t299 r0 *1 0,0
RVDD_t299 VDD__t299 VDD 0.745022623242
* device instance VDD_t300 r0 *1 0,0
RVDD_t300 VDD__t300 VDD 0.246246219433
* device instance VDD_t301 r0 *1 0,0
RVDD_t301 VDD__t301 VDD 0.721271365918
* device instance VDD_t302 r0 *1 0,0
RVDD_t302 VDD__t302 VDD 0.103738675488
* device instance VDD_t303 r0 *1 0,0
RVDD_t303 VDD__t303 VDD 1.34508802129
* device instance VDD_t304 r0 *1 0,0
RVDD_t304 VDD__t304 VDD 1.36883927861
* device instance VDD_t305 r0 *1 0,0
RVDD_t305 VDD__t305 VDD 1.39259053594
* device instance VDD_t306 r0 *1 0,0
RVDD_t306 VDD__t306 VDD 1.41634179326
* device instance VDD_t307 r0 *1 0,0
RVDD_t307 VDD__t307 VDD 1.44009305059
* device instance VDD_t308 r0 *1 0,0
RVDD_t308 VDD__t308 VDD 1.46384430791
* device instance VDD_t309 r0 *1 0,0
RVDD_t309 VDD__t309 VDD 1.48759556523
* device instance VDD_t310 r0 *1 0,0
RVDD_t310 VDD__t310 VDD 1.33880405635
* device instance VDD_t311 r0 *1 0,0
RVDD_t311 VDD__t311 VDD 0.205027669727
* device instance VDD_t312 r0 *1 0,0
RVDD_t312 VDD__t312 VDD 1.386306571
* device instance VDD_t313 r0 *1 0,0
RVDD_t313 VDD__t313 VDD 1.41005782832
* device instance VDD_t314 r0 *1 0,0
RVDD_t314 VDD__t314 VDD 1.43380908564
* device instance VDD_t315 r0 *1 0,0
RVDD_t315 VDD__t315 VDD 1.45756034297
* device instance VDD_t316 r0 *1 0,0
RVDD_t316 VDD__t316 VDD 1.48131160029
* device instance VDD_t317 r0 *1 0,0
RVDD_t317 VDD__t317 VDD 1.50506285762
* device instance VDD_t318 r0 *1 0,0
RVDD_t318 VDD__t318 VDD 0.133773897754
* device instance VDD_t319 r0 *1 0,0
RVDD_t319 VDD__t319 VDD 0.157525155079
* device instance VDD_t320 r0 *1 0,0
RVDD_t320 VDD__t320 VDD 0.181276412403
* device instance VDD_t321 r0 *1 0,0
RVDD_t321 VDD__t321 VDD 1.36255531367
* device instance VDD_t322 r0 *1 0,0
RVDD_t322 VDD__t322 VDD 0.0150176111333
* device instance VDD_t323 r0 *1 0,0
RVDD_t323 VDD__t323 VDD 0.0387688684575
* device instance VDD_t324 r0 *1 0,0
RVDD_t324 VDD__t324 VDD 0.0625201257817
* device instance VDD_t325 r0 *1 0,0
RVDD_t325 VDD__t325 VDD 0.0862713831059
* device instance VDD_t326 r0 *1 0,0
RVDD_t326 VDD__t326 VDD 0.11002264043
* device instance VDD_t327 r0 *1 0,0
RVDD_t327 VDD__t327 VDD 1.14879399775
* device instance VDD_t328 r0 *1 0,0
RVDD_t328 VDD__t328 VDD 1.17254525508
* device instance VDD_t329 r0 *1 0,0
RVDD_t329 VDD__t329 VDD 1.1962965124
* device instance VDD_t330 r0 *1 0,0
RVDD_t330 VDD__t330 VDD 1.22004776973
* device instance VDD_t331 r0 *1 0,0
RVDD_t331 VDD__t331 VDD 1.32133676397
* device instance VDD_t332 r0 *1 0,0
RVDD_t332 VDD__t332 VDD 1.26755028437
* device instance VDD_t333 r0 *1 0,0
RVDD_t333 VDD__t333 VDD 1.2913015417
* device instance VDD_t334 r0 *1 0,0
RVDD_t334 VDD__t334 VDD 1.31505279902
* device instance VDD_t335 r0 *1 0,0
RVDD_t335 VDD__t335 VDD 1.1550779627
* device instance VDD_t336 r0 *1 0,0
RVDD_t336 VDD__t336 VDD 1.17882922002
* device instance VDD_t337 r0 *1 0,0
RVDD_t337 VDD__t337 VDD 1.20258047734
* device instance VDD_t338 r0 *1 0,0
RVDD_t338 VDD__t338 VDD 1.22633173467
* device instance VDD_t339 r0 *1 0,0
RVDD_t339 VDD__t339 VDD 1.25008299199
* device instance VDD_t340 r0 *1 0,0
RVDD_t340 VDD__t340 VDD 1.27383424932
* device instance VDD_t341 r0 *1 0,0
RVDD_t341 VDD__t341 VDD 1.29758550664
* device instance VDD_t342 r0 *1 0,0
RVDD_t342 VDD__t342 VDD 1.24379902705
* device instance VDD_t343 r0 *1 0,0
RVDD_t343 VDD__t343 VDD 0.911281424511
* device instance VDD_t344 r0 *1 0,0
RVDD_t344 VDD__t344 VDD 0.935032681835
* device instance VDD_t345 r0 *1 0,0
RVDD_t345 VDD__t345 VDD 0.95878393916
* device instance VDD_t346 r0 *1 0,0
RVDD_t346 VDD__t346 VDD 0.982535196484
* device instance VDD_t347 r0 *1 0,0
RVDD_t347 VDD__t347 VDD 1.00628645381
* device instance VDD_t348 r0 *1 0,0
RVDD_t348 VDD__t348 VDD 1.03003771113
* device instance VDD_t349 r0 *1 0,0
RVDD_t349 VDD__t349 VDD 1.05378896846
* device instance VDD_t350 r0 *1 0,0
RVDD_t350 VDD__t350 VDD 1.07754022578
* device instance VDD_t351 r0 *1 0,0
RVDD_t351 VDD__t351 VDD 1.10129148311
* device instance VDD_t352 r0 *1 0,0
RVDD_t352 VDD__t352 VDD 0.863778909863
* device instance VDD_t353 r0 *1 0,0
RVDD_t353 VDD__t353 VDD 0.228778927051
* device instance VDD_t354 r0 *1 0,0
RVDD_t354 VDD__t354 VDD 0.252530184375
* device instance VDD_t355 r0 *1 0,0
RVDD_t355 VDD__t355 VDD 0.2762814417
* device instance VDD_t356 r0 *1 0,0
RVDD_t356 VDD__t356 VDD 0.300032699024
* device instance VDD_t357 r0 *1 0,0
RVDD_t357 VDD__t357 VDD 0.388753763378
* device instance VDD_t358 r0 *1 0,0
RVDD_t358 VDD__t358 VDD 0.412505020703
* device instance VDD_t359 r0 *1 0,0
RVDD_t359 VDD__t359 VDD 0.436256278027
* device instance VDD_t360 r0 *1 0,0
RVDD_t360 VDD__t360 VDD 0.460007535351
* device instance VDD_t361 r0 *1 0,0
RVDD_t361 VDD__t361 VDD 0.483758792675
* device instance VDD_t362 r0 *1 0,0
RVDD_t362 VDD__t362 VDD 0.887530167187
* device instance VDD_t363 r0 *1 0,0
RVDD_t363 VDD__t363 VDD 1.12504274043
* device instance VDD_t364 r0 *1 0,0
RVDD_t364 VDD__t364 VDD 0.50751005
* device instance VDD_t365 r0 *1 0,0
RVDD_t365 VDD__t365 VDD 0.79252513789
* device instance VDD_t366 r0 *1 0,0
RVDD_t366 VDD__t366 VDD 0.816276395214
* device instance VDD_t367 r0 *1 0,0
RVDD_t367 VDD__t367 VDD 0.840027652539
* device instance VDD_t368 r0 *1 0,0
RVDD_t368 VDD__t368 VDD 0.775057845508
* device instance VDD_t369 r0 *1 0,0
RVDD_t369 VDD__t369 VDD 0.798809102832
* device instance VDD_t370 r0 *1 0,0
RVDD_t370 VDD__t370 VDD 0.822560360157
* device instance VDD_t371 r0 *1 0,0
RVDD_t371 VDD__t371 VDD 0.846311617481
* device instance VDD_t372 r0 *1 0,0
RVDD_t372 VDD__t372 VDD 0.870062874805
* device instance VDD_t373 r0 *1 0,0
RVDD_t373 VDD__t373 VDD 0.893814132129
* device instance VDD_t374 r0 *1 0,0
RVDD_t374 VDD__t374 VDD 0.917565389454
* device instance VDD_t375 r0 *1 0,0
RVDD_t375 VDD__t375 VDD 0.941316646778
* device instance VDD_t376 r0 *1 0,0
RVDD_t376 VDD__t376 VDD 0.965067904102
* device instance VDD_t377 r0 *1 0,0
RVDD_t377 VDD__t377 VDD 0.988819161426
* device instance VDD_t378 r0 *1 0,0
RVDD_t378 VDD__t378 VDD 1.01257041875
* device instance VDD_t379 r0 *1 0,0
RVDD_t379 VDD__t379 VDD 1.03632167607
* device instance VDD_t380 r0 *1 0,0
RVDD_t380 VDD__t380 VDD 1.0600729334
* device instance VDD_t381 r0 *1 0,0
RVDD_t381 VDD__t381 VDD 1.08382419072
* device instance VDD_t382 r0 *1 0,0
RVDD_t382 VDD__t382 VDD 1.10757544805
* device instance VDD_t383 r0 *1 0,0
RVDD_t383 VDD__t383 VDD 0.768773880566
* device instance VDD_t384 r0 *1 0,0
RVDD_t384 VDD__t384 VDD 1.13132670537
* device instance VDD_t385 r0 *1 0,0
RVDD_t385 VDD__t385 VDD 0.816276395214
* device instance VDD_t386 r0 *1 0,0
RVDD_t386 VDD__t386 VDD 0.840027652539
* device instance VDD_t387 r0 *1 0,0
RVDD_t387 VDD__t387 VDD 0.650017593945
* device instance VDD_t388 r0 *1 0,0
RVDD_t388 VDD__t388 VDD 0.863778909863
* device instance VDD_t389 r0 *1 0,0
RVDD_t389 VDD__t389 VDD 0.887530167187
* device instance VDD_t390 r0 *1 0,0
RVDD_t390 VDD__t390 VDD 0.673768851269
* device instance VDD_t391 r0 *1 0,0
RVDD_t391 VDD__t391 VDD 0.911281424511
* device instance VDD_t392 r0 *1 0,0
RVDD_t392 VDD__t392 VDD 0.935032681835
* device instance VDD_t393 r0 *1 0,0
RVDD_t393 VDD__t393 VDD 1.44009305059
* device instance VDD_t394 r0 *1 0,0
RVDD_t394 VDD__t394 VDD 0.95878393916
* device instance VDD_t395 r0 *1 0,0
RVDD_t395 VDD__t395 VDD 0.982535196484
* device instance VDD_t396 r0 *1 0,0
RVDD_t396 VDD__t396 VDD 0.721271365918
* device instance VDD_t397 r0 *1 0,0
RVDD_t397 VDD__t397 VDD 1.00628645381
* device instance VDD_t398 r0 *1 0,0
RVDD_t398 VDD__t398 VDD 1.03003771113
* device instance VDD_t399 r0 *1 0,0
RVDD_t399 VDD__t399 VDD 0.745022623242
* device instance VDD_t400 r0 *1 0,0
RVDD_t400 VDD__t400 VDD 1.05378896846
* device instance VDD_t401 r0 *1 0,0
RVDD_t401 VDD__t401 VDD 1.07754022578
* device instance VDD_t402 r0 *1 0,0
RVDD_t402 VDD__t402 VDD 0.697520108593
* device instance VDD_t403 r0 *1 0,0
RVDD_t403 VDD__t403 VDD 0.483758792675
* device instance VDD_t404 r0 *1 0,0
RVDD_t404 VDD__t404 VDD 1.46384430791
* device instance VDD_t405 r0 *1 0,0
RVDD_t405 VDD__t405 VDD 1.48759556523
* device instance VDD_t406 r0 *1 0,0
RVDD_t406 VDD__t406 VDD 0.50751005
* device instance VDD_t407 r0 *1 0,0
RVDD_t407 VDD__t407 VDD 1.51134682256
* device instance VDD_t408 r0 *1 0,0
RVDD_t408 VDD__t408 VDD 0.151241190136
* device instance VDD_t409 r0 *1 0,0
RVDD_t409 VDD__t409 VDD 0.531261307324
* device instance VDD_t410 r0 *1 0,0
RVDD_t410 VDD__t410 VDD 0.17499244746
* device instance VDD_t411 r0 *1 0,0
RVDD_t411 VDD__t411 VDD 0.626266336621
* device instance VDD_t412 r0 *1 0,0
RVDD_t412 VDD__t412 VDD 0.222494962109
* device instance VDD_t413 r0 *1 0,0
RVDD_t413 VDD__t413 VDD 0.775057845508
* device instance VDD_t414 r0 *1 0,0
RVDD_t414 VDD__t414 VDD 0.578763821972
* device instance VDD_t415 r0 *1 0,0
RVDD_t415 VDD__t415 VDD 0.798809102832
* device instance VDD_t416 r0 *1 0,0
RVDD_t416 VDD__t416 VDD 0.822560360157
* device instance VDD_t417 r0 *1 0,0
RVDD_t417 VDD__t417 VDD 0.602515079296
* device instance VDD_t418 r0 *1 0,0
RVDD_t418 VDD__t418 VDD 0.846311617481
* device instance VDD_t419 r0 *1 0,0
RVDD_t419 VDD__t419 VDD 0.768773880566
* device instance VDD_t420 r0 *1 0,0
RVDD_t420 VDD__t420 VDD 0.79252513789
* device instance VDD_t421 r0 *1 0,0
RVDD_t421 VDD__t421 VDD 0.198743704785
* device instance VDD_t422 r0 *1 0,0
RVDD_t422 VDD__t422 VDD 0.656301558887
* device instance VDD_t423 r0 *1 0,0
RVDD_t423 VDD__t423 VDD 1.13132670537
* device instance VDD_t424 r0 *1 0,0
RVDD_t424 VDD__t424 VDD 0.246246219433
* device instance VDD_t425 r0 *1 0,0
RVDD_t425 VDD__t425 VDD 0.632550301563
* device instance VDD_t426 r0 *1 0,0
RVDD_t426 VDD__t426 VDD 0.269997476757
* device instance VDD_t427 r0 *1 0,0
RVDD_t427 VDD__t427 VDD 0.293748734082
* device instance VDD_t428 r0 *1 0,0
RVDD_t428 VDD__t428 VDD 0.608799044239
* device instance VDD_t429 r0 *1 0,0
RVDD_t429 VDD__t429 VDD 0.317499991406
* device instance VDD_t430 r0 *1 0,0
RVDD_t430 VDD__t430 VDD 1.10129148311
* device instance VDD_t431 r0 *1 0,0
RVDD_t431 VDD__t431 VDD 0.585047786915
* device instance VDD_t432 r0 *1 0,0
RVDD_t432 VDD__t432 VDD 0.418788985645
* device instance VDD_t433 r0 *1 0,0
RVDD_t433 VDD__t433 VDD 0.442540242969
* device instance VDD_t434 r0 *1 0,0
RVDD_t434 VDD__t434 VDD 0.56129652959
* device instance VDD_t435 r0 *1 0,0
RVDD_t435 VDD__t435 VDD 0.466291500293
* device instance VDD_t436 r0 *1 0,0
RVDD_t436 VDD__t436 VDD 0.490042757618
* device instance VDD_t437 r0 *1 0,0
RVDD_t437 VDD__t437 VDD 0.537545272266
* device instance VDD_t438 r0 *1 0,0
RVDD_t438 VDD__t438 VDD 0.513794014942
* device instance VDD_t439 r0 *1 0,0
RVDD_t439 VDD__t439 VDD 0.395037728321
* device instance VDD_t440 r0 *1 0,0
RVDD_t440 VDD__t440 VDD 0.365002506054
* device instance VDD_t441 r0 *1 0,0
RVDD_t441 VDD__t441 VDD 1.12504274043
* device instance VDD_t442 r0 *1 0,0
RVDD_t442 VDD__t442 VDD 0.34125124873
* device instance VDD_t443 r0 *1 0,0
RVDD_t443 VDD__t443 VDD 0.870062874805
* device instance VDD_t444 r0 *1 0,0
RVDD_t444 VDD__t444 VDD 0.436256278027
* device instance VDD_t445 r0 *1 0,0
RVDD_t445 VDD__t445 VDD 0.893814132129
* device instance VDD_t446 r0 *1 0,0
RVDD_t446 VDD__t446 VDD 0.917565389454
* device instance VDD_t447 r0 *1 0,0
RVDD_t447 VDD__t447 VDD 0.751306588184
* device instance VDD_t448 r0 *1 0,0
RVDD_t448 VDD__t448 VDD 1.10757544805
* device instance VDD_t449 r0 *1 0,0
RVDD_t449 VDD__t449 VDD 0.965067904102
* device instance VDD_t450 r0 *1 0,0
RVDD_t450 VDD__t450 VDD 0.72755533086
* device instance VDD_t451 r0 *1 0,0
RVDD_t451 VDD__t451 VDD 0.988819161426
* device instance VDD_t452 r0 *1 0,0
RVDD_t452 VDD__t452 VDD 1.01257041875
* device instance VDD_t453 r0 *1 0,0
RVDD_t453 VDD__t453 VDD 0.703804073536
* device instance VDD_t454 r0 *1 0,0
RVDD_t454 VDD__t454 VDD 1.03632167607
* device instance VDD_t455 r0 *1 0,0
RVDD_t455 VDD__t455 VDD 1.0600729334
* device instance VDD_t456 r0 *1 0,0
RVDD_t456 VDD__t456 VDD 0.680052816211
* device instance VDD_t457 r0 *1 0,0
RVDD_t457 VDD__t457 VDD 1.08382419072
* device instance VDD_t458 r0 *1 0,0
RVDD_t458 VDD__t458 VDD 0.941316646778
* device instance VDD_t459 r0 *1 0,0
RVDD_t459 VDD__t459 VDD 1.386306571
* device instance VDD_t460 r0 *1 0,0
RVDD_t460 VDD__t460 VDD 0.0799874181636
* device instance VDD_t461 r0 *1 0,0
RVDD_t461 VDD__t461 VDD 1.36255531367
* device instance VDD_t462 r0 *1 0,0
RVDD_t462 VDD__t462 VDD 1.29758550664
* device instance VDD_t463 r0 *1 0,0
RVDD_t463 VDD__t463 VDD 0.11002264043
* device instance VDD_t464 r0 *1 0,0
RVDD_t464 VDD__t464 VDD 1.33880405635
* device instance VDD_t465 r0 *1 0,0
RVDD_t465 VDD__t465 VDD 0.323783956348
* device instance VDD_t466 r0 *1 0,0
RVDD_t466 VDD__t466 VDD 0.103738675488
* device instance VDD_t467 r0 *1 0,0
RVDD_t467 VDD__t467 VDD 1.31505279902
* device instance VDD_t468 r0 *1 0,0
RVDD_t468 VDD__t468 VDD 0.133773897754
* device instance VDD_t469 r0 *1 0,0
RVDD_t469 VDD__t469 VDD 1.2913015417
* device instance VDD_t470 r0 *1 0,0
RVDD_t470 VDD__t470 VDD 0.2762814417
* device instance VDD_t471 r0 *1 0,0
RVDD_t471 VDD__t471 VDD 0.205027669727
* device instance VDD_t472 r0 *1 0,0
RVDD_t472 VDD__t472 VDD 1.26755028437
* device instance VDD_t473 r0 *1 0,0
RVDD_t473 VDD__t473 VDD 0.157525155079
* device instance VDD_t474 r0 *1 0,0
RVDD_t474 VDD__t474 VDD 0.127489932812
* device instance VDD_t475 r0 *1 0,0
RVDD_t475 VDD__t475 VDD 1.24379902705
* device instance VDD_t476 r0 *1 0,0
RVDD_t476 VDD__t476 VDD 0.300032699024
* device instance VDD_t477 r0 *1 0,0
RVDD_t477 VDD__t477 VDD 1.22004776973
* device instance VDD_t478 r0 *1 0,0
RVDD_t478 VDD__t478 VDD 1.1550779627
* device instance VDD_t479 r0 *1 0,0
RVDD_t479 VDD__t479 VDD 0.181276412403
* device instance VDD_t480 r0 *1 0,0
RVDD_t480 VDD__t480 VDD 0.555012564648
* device instance VDD_t481 r0 *1 0,0
RVDD_t481 VDD__t481 VDD 1.1962965124
* device instance VDD_t482 r0 *1 0,0
RVDD_t482 VDD__t482 VDD 1.32133676397
* device instance VDD_t483 r0 *1 0,0
RVDD_t483 VDD__t483 VDD 1.17254525508
* device instance VDD_t484 r0 *1 0,0
RVDD_t484 VDD__t484 VDD 1.14879399775
* device instance VDD_t485 r0 *1 0,0
RVDD_t485 VDD__t485 VDD 1.17882922002
* device instance VDD_t486 r0 *1 0,0
RVDD_t486 VDD__t486 VDD 1.22633173467
* device instance VDD_t487 r0 *1 0,0
RVDD_t487 VDD__t487 VDD 1.41634179326
* device instance VDD_t488 r0 *1 0,0
RVDD_t488 VDD__t488 VDD 0.412505020703
* device instance VDD_t489 r0 *1 0,0
RVDD_t489 VDD__t489 VDD 0.460007535351
* device instance VDD_t490 r0 *1 0,0
RVDD_t490 VDD__t490 VDD 1.39259053594
* device instance VDD_t491 r0 *1 0,0
RVDD_t491 VDD__t491 VDD 0.252530184375
* device instance VDD_t492 r0 *1 0,0
RVDD_t492 VDD__t492 VDD 1.25008299199
* device instance VDD_t493 r0 *1 0,0
RVDD_t493 VDD__t493 VDD 1.36883927861
* device instance VDD_t494 r0 *1 0,0
RVDD_t494 VDD__t494 VDD 0.388753763378
* device instance VDD_t495 r0 *1 0,0
RVDD_t495 VDD__t495 VDD 1.34508802129
* device instance VDD_t496 r0 *1 0,0
RVDD_t496 VDD__t496 VDD 0.371286470997
* device instance VDD_t497 r0 *1 0,0
RVDD_t497 VDD__t497 VDD 0.0150176111333
* device instance VDD_t498 r0 *1 0,0
RVDD_t498 VDD__t498 VDD 0.00873364619097
* device instance VDD_t499 r0 *1 0,0
RVDD_t499 VDD__t499 VDD 0.228778927051
* device instance VDD_t500 r0 *1 0,0
RVDD_t500 VDD__t500 VDD 0.0387688684575
* device instance VDD_t501 r0 *1 0,0
RVDD_t501 VDD__t501 VDD 1.48131160029
* device instance VDD_t502 r0 *1 0,0
RVDD_t502 VDD__t502 VDD 0.0324849035152
* device instance VDD_t503 r0 *1 0,0
RVDD_t503 VDD__t503 VDD 0.347535213672
* device instance VDD_t504 r0 *1 0,0
RVDD_t504 VDD__t504 VDD 1.45756034297
* device instance VDD_t505 r0 *1 0,0
RVDD_t505 VDD__t505 VDD 0.0625201257817
* device instance VDD_t506 r0 *1 0,0
RVDD_t506 VDD__t506 VDD 1.43380908564
* device instance VDD_t507 r0 *1 0,0
RVDD_t507 VDD__t507 VDD 1.27383424932
* device instance VDD_t508 r0 *1 0,0
RVDD_t508 VDD__t508 VDD 0.0562361608394
* device instance VDD_t509 r0 *1 0,0
RVDD_t509 VDD__t509 VDD 1.41005782832
* device instance VDD_t510 r0 *1 0,0
RVDD_t510 VDD__t510 VDD 0.0862713831059
* device instance VDD_t511 r0 *1 0,0
RVDD_t511 VDD__t511 VDD 1.20258047734
* device instance VDD r0 *1 0,0
CVDD VDD vsubs 1.34131197e-13
* device instance VSS_t0 r0 *1 0,0
RVSS_t0 VSS__t0 VSS 1.00039036958
* device instance VSS_t1 r0 *1 0,0
RVSS_t1 VSS__t1 VSS 1.00456721704
* device instance VSS_t2 r0 *1 0,0
RVSS_t2 VSS__t2 VSS 0.136278516486
* device instance VSS_t3 r0 *1 0,0
RVSS_t3 VSS__t3 VSS 0.068953416678
* device instance VSS_t4 r0 *1 0,0
RVSS_t4 VSS__t4 VSS 0.668861951812
* device instance VSS_t5 r0 *1 0,0
RVSS_t5 VSS__t5 VSS 0.447843007655
* device instance VSS_t6 r0 *1 0,0
RVSS_t6 VSS__t6 VSS 0.515168124685
* device instance VSS_t7 r0 *1 0,0
RVSS_t7 VSS__t7 VSS 0.826732626814
* device instance VSS_t8 r0 *1 0,0
RVSS_t8 VSS__t8 VSS 0.432055940288
* device instance VSS_t9 r0 *1 0,0
RVSS_t9 VSS__t9 VSS 0.416268872936
* device instance VSS_t10 r0 *1 0,0
RVSS_t10 VSS__t10 VSS 0.546742259548
* device instance VSS_t11 r0 *1 0,0
RVSS_t11 VSS__t11 VSS 0.294149182335
* device instance VSS_t12 r0 *1 0,0
RVSS_t12 VSS__t12 VSS 0.400481805601
* device instance VSS_t13 r0 *1 0,0
RVSS_t13 VSS__t13 VSS 0.2152138476
* device instance VSS_t14 r0 *1 0,0
RVSS_t14 VSS__t14 VSS 0.562529326991
* device instance VSS_t15 r0 *1 0,0
RVSS_t15 VSS__t15 VSS 0.810945559301
* device instance VSS_t16 r0 *1 0,0
RVSS_t16 VSS__t16 VSS 0.384694738286
* device instance VSS_t17 r0 *1 0,0
RVSS_t17 VSS__t17 VSS 0.530955192112
* device instance VSS_t18 r0 *1 0,0
RVSS_t18 VSS__t18 VSS 0.716223154279
* device instance VSS_t19 r0 *1 0,0
RVSS_t19 VSS__t19 VSS 0.0373793122322
* device instance VSS_t20 r0 *1 0,0
RVSS_t20 VSS__t20 VSS 0.846696541789
* device instance VSS_t21 r0 *1 0,0
RVSS_t21 VSS__t21 VSS 0.325723316653
* device instance VSS_t22 r0 *1 0,0
RVSS_t22 VSS__t22 VSS 0.0215922936761
* device instance VSS_t23 r0 *1 0,0
RVSS_t23 VSS__t23 VSS 0.246787981254
* device instance VSS_t24 r0 *1 0,0
RVSS_t24 VSS__t24 VSS 0.732010221776
* device instance VSS_t25 r0 *1 0,0
RVSS_t25 VSS__t25 VSS 0.700436086786
* device instance VSS_t26 r0 *1 0,0
RVSS_t26 VSS__t26 VSS 0.231000914376
* device instance VSS_t27 r0 *1 0,0
RVSS_t27 VSS__t27 VSS 0.747797289275
* device instance VSS_t28 r0 *1 0,0
RVSS_t28 VSS__t28 VSS 0.495204209835
* device instance VSS_t29 r0 *1 0,0
RVSS_t29 VSS__t29 VSS 0.862483609306
* device instance VSS_t30 r0 *1 0,0
RVSS_t30 VSS__t30 VSS 0.47941714243
* device instance VSS_t31 r0 *1 0,0
RVSS_t31 VSS__t31 VSS 0.0531663598974
* device instance VSS_t32 r0 *1 0,0
RVSS_t32 VSS__t32 VSS 0.684649019297
* device instance VSS_t33 r0 *1 0,0
RVSS_t33 VSS__t33 VSS 0.878270676826
* device instance VSS_t34 r0 *1 0,0
RVSS_t34 VSS__t34 VSS 0.309936249473
* device instance VSS_t35 r0 *1 0,0
RVSS_t35 VSS__t35 VSS 0.463630075036
* device instance VSS_t36 r0 *1 0,0
RVSS_t36 VSS__t36 VSS 0.00580554170366
* device instance VSS_t37 r0 *1 0,0
RVSS_t37 VSS__t37 VSS 0.894057744347
* device instance VSS_t38 r0 *1 0,0
RVSS_t38 VSS__t38 VSS 0.589926614454
* device instance VSS_t39 r0 *1 0,0
RVSS_t39 VSS__t39 VSS 0.625677596829
* device instance VSS_t40 r0 *1 0,0
RVSS_t40 VSS__t40 VSS 0.751974136731
* device instance VSS_t41 r0 *1 0,0
RVSS_t41 VSS__t41 VSS 0.183639714459
* device instance VSS_t42 r0 *1 0,0
RVSS_t42 VSS__t42 VSS 0.605713681915
* device instance VSS_t43 r0 *1 0,0
RVSS_t43 VSS__t43 VSS 0.73618706923
* device instance VSS_t44 r0 *1 0,0
RVSS_t44 VSS__t44 VSS 0.720400001733
* device instance VSS_t45 r0 *1 0,0
RVSS_t45 VSS__t45 VSS 0.842519694329
* device instance VSS_t46 r0 *1 0,0
RVSS_t46 VSS__t46 VSS 0.621500749382
* device instance VSS_t47 r0 *1 0,0
RVSS_t47 VSS__t47 VSS 0.704612934239
* device instance VSS_t48 r0 *1 0,0
RVSS_t48 VSS__t48 VSS 0.16785264817
* device instance VSS_t49 r0 *1 0,0
RVSS_t49 VSS__t49 VSS 0.641464664302
* device instance VSS_t50 r0 *1 0,0
RVSS_t50 VSS__t50 VSS 0.688825866749
* device instance VSS_t51 r0 *1 0,0
RVSS_t51 VSS__t51 VSS 0.152065582148
* device instance VSS_t52 r0 *1 0,0
RVSS_t52 VSS__t52 VSS 0.763584356778
* device instance VSS_t53 r0 *1 0,0
RVSS_t53 VSS__t53 VSS 0.65725173178
* device instance VSS_t54 r0 *1 0,0
RVSS_t54 VSS__t54 VSS 0.673038799262
* device instance VSS_t55 r0 *1 0,0
RVSS_t55 VSS__t55 VSS 0.779371424283
* device instance VSS_t56 r0 *1 0,0
RVSS_t56 VSS__t56 VSS 0.578316394441
* device instance VSS_t57 r0 *1 0,0
RVSS_t57 VSS__t57 VSS 0.368907670993
* device instance VSS_t58 r0 *1 0,0
RVSS_t58 VSS__t58 VSS 0.594103461898
* device instance VSS_t59 r0 *1 0,0
RVSS_t59 VSS__t59 VSS 0.353120603725
* device instance VSS_t60 r0 *1 0,0
RVSS_t60 VSS__t60 VSS 0.278362115246
* device instance VSS_t61 r0 *1 0,0
RVSS_t61 VSS__t61 VSS 0.337333536485
* device instance VSS_t62 r0 *1 0,0
RVSS_t62 VSS__t62 VSS 0.510991277251
* device instance VSS_t63 r0 *1 0,0
RVSS_t63 VSS__t63 VSS 0.19942678095
* device instance VSS_t64 r0 *1 0,0
RVSS_t64 VSS__t64 VSS 0.795158491791
* device instance VSS_t65 r0 *1 0,0
RVSS_t65 VSS__t65 VSS 0.258398200896
* device instance VSS_t66 r0 *1 0,0
RVSS_t66 VSS__t66 VSS 0.526778344676
* device instance VSS_t67 r0 *1 0,0
RVSS_t67 VSS__t67 VSS 0.609890529361
* device instance VSS_t68 r0 *1 0,0
RVSS_t68 VSS__t68 VSS 0.305759402109
* device instance VSS_t69 r0 *1 0,0
RVSS_t69 VSS__t69 VSS 0.542565412109
* device instance VSS_t70 r0 *1 0,0
RVSS_t70 VSS__t70 VSS 0.289972334983
* device instance VSS_t71 r0 *1 0,0
RVSS_t71 VSS__t71 VSS 0.55835247955
* device instance VSS_t72 r0 *1 0,0
RVSS_t72 VSS__t72 VSS 0.262575048216
* device instance VSS_t73 r0 *1 0,0
RVSS_t73 VSS__t73 VSS 0.274185267909
* device instance VSS_t74 r0 *1 0,0
RVSS_t74 VSS__t74 VSS 0.574139546999
* device instance VSS_t75 r0 *1 0,0
RVSS_t75 VSS__t75 VSS 0.321546469278
* device instance VSS_t76 r0 *1 0,0
RVSS_t76 VSS__t76 VSS 0.0573432039384
* device instance VSS_t77 r0 *1 0,0
RVSS_t77 VSS__t77 VSS 0.78354827174
* device instance VSS_t78 r0 *1 0,0
RVSS_t78 VSS__t78 VSS 0.179462867302
* device instance VSS_t79 r0 *1 0,0
RVSS_t79 VSS__t79 VSS 0.905667964409
* device instance VSS_t80 r0 *1 0,0
RVSS_t80 VSS__t80 VSS 0.436232787706
* device instance VSS_t81 r0 *1 0,0
RVSS_t81 VSS__t81 VSS 0.195249933745
* device instance VSS_t82 r0 *1 0,0
RVSS_t82 VSS__t82 VSS 0.483593989859
* device instance VSS_t83 r0 *1 0,0
RVSS_t83 VSS__t83 VSS 0.968816234516
* device instance VSS_t84 r0 *1 0,0
RVSS_t84 VSS__t84 VSS 0.941418946922
* device instance VSS_t85 r0 *1 0,0
RVSS_t85 VSS__t85 VSS 0.211037000357
* device instance VSS_t86 r0 *1 0,0
RVSS_t86 VSS__t86 VSS 0.373084518391
* device instance VSS_t87 r0 *1 0,0
RVSS_t87 VSS__t87 VSS 0.104704386887
* device instance VSS_t88 r0 *1 0,0
RVSS_t88 VSS__t88 VSS 0.226824067102
* device instance VSS_t89 r0 *1 0,0
RVSS_t89 VSS__t89 VSS 0.120491451323
* device instance VSS_t90 r0 *1 0,0
RVSS_t90 VSS__t90 VSS 0.98878014951
* device instance VSS_t91 r0 *1 0,0
RVSS_t91 VSS__t91 VSS 0.242611133955
* device instance VSS_t92 r0 *1 0,0
RVSS_t92 VSS__t92 VSS 0.984603302046
* device instance VSS_t93 r0 *1 0,0
RVSS_t93 VSS__t93 VSS 0.452019855078
* device instance VSS_t94 r0 *1 0,0
RVSS_t94 VSS__t94 VSS 0.874093829365
* device instance VSS_t95 r0 *1 0,0
RVSS_t95 VSS__t95 VSS 0.388871585691
* device instance VSS_t96 r0 *1 0,0
RVSS_t96 VSS__t96 VSS 0.0731302620765
* device instance VSS_t97 r0 *1 0,0
RVSS_t97 VSS__t97 VSS 0.972993081979
* device instance VSS_t98 r0 *1 0,0
RVSS_t98 VSS__t98 VSS 0.0889173235644
* device instance VSS_t99 r0 *1 0,0
RVSS_t99 VSS__t99 VSS 0.404658653011
* device instance VSS_t100 r0 *1 0,0
RVSS_t100 VSS__t100 VSS 0.95720601445
* device instance VSS_t101 r0 *1 0,0
RVSS_t101 VSS__t101 VSS 0.42044572035
* device instance VSS_t102 r0 *1 0,0
RVSS_t102 VSS__t102 VSS 0.889880896886
* device instance VSS_t103 r0 *1 0,0
RVSS_t103 VSS__t103 VSS 1.00039036958
* device instance VSS_t104 r0 *1 0,0
RVSS_t104 VSS__t104 VSS 0.467806922462
* device instance VSS_t105 r0 *1 0,0
RVSS_t105 VSS__t105 VSS 0.0847404774793
* device instance VSS_t106 r0 *1 0,0
RVSS_t106 VSS__t106 VSS 0.0415561529681
* device instance VSS_t107 r0 *1 0,0
RVSS_t107 VSS__t107 VSS 0.341510383869
* device instance VSS_t108 r0 *1 0,0
RVSS_t108 VSS__t108 VSS 0.921455031934
* device instance VSS_t109 r0 *1 0,0
RVSS_t109 VSS__t109 VSS 0.830909474273
* device instance VSS_t110 r0 *1 0,0
RVSS_t110 VSS__t110 VSS 0.100527540407
* device instance VSS_t111 r0 *1 0,0
RVSS_t111 VSS__t111 VSS 0.65307488433
* device instance VSS_t112 r0 *1 0,0
RVSS_t112 VSS__t112 VSS 0.0257691223392
* device instance VSS_t113 r0 *1 0,0
RVSS_t113 VSS__t113 VSS 0.925631879395
* device instance VSS_t114 r0 *1 0,0
RVSS_t114 VSS__t114 VSS 0.909844811871
* device instance VSS_t115 r0 *1 0,0
RVSS_t115 VSS__t115 VSS 0.116314604596
* device instance VSS_t116 r0 *1 0,0
RVSS_t116 VSS__t116 VSS 0.767761204234
* device instance VSS_t117 r0 *1 0,0
RVSS_t117 VSS__t117 VSS 0.93724209946
* device instance VSS_t118 r0 *1 0,0
RVSS_t118 VSS__t118 VSS 0.132101669593
* device instance VSS_t119 r0 *1 0,0
RVSS_t119 VSS__t119 VSS 0.00998220856247
* device instance VSS_t120 r0 *1 0,0
RVSS_t120 VSS__t120 VSS 0.357297451116
* device instance VSS_t121 r0 *1 0,0
RVSS_t121 VSS__t121 VSS 0.953029166987
* device instance VSS_t122 r0 *1 0,0
RVSS_t122 VSS__t122 VSS 0.637287816854
* device instance VSS_t123 r0 *1 0,0
RVSS_t123 VSS__t123 VSS 0.14788873514
* device instance VSS_t124 r0 *1 0,0
RVSS_t124 VSS__t124 VSS 0.858306761846
* device instance VSS_t125 r0 *1 0,0
RVSS_t125 VSS__t125 VSS 0.799335339249
* device instance VSS_t126 r0 *1 0,0
RVSS_t126 VSS__t126 VSS 0.81512240676
* device instance VSS_t127 r0 *1 0,0
RVSS_t127 VSS__t127 VSS 0.163675801077
* device instance VSS_t128 r0 *1 0,0
RVSS_t128 VSS__t128 VSS 0.499381057267
* device instance VSS_t129 r0 *1 0,0
RVSS_t129 VSS__t129 VSS 0.242611133955
* device instance VSS_t130 r0 *1 0,0
RVSS_t130 VSS__t130 VSS 0.226824067102
* device instance VSS_t131 r0 *1 0,0
RVSS_t131 VSS__t131 VSS 0.211037000357
* device instance VSS_t132 r0 *1 0,0
RVSS_t132 VSS__t132 VSS 0.195249933745
* device instance VSS_t133 r0 *1 0,0
RVSS_t133 VSS__t133 VSS 0.163675801077
* device instance VSS_t134 r0 *1 0,0
RVSS_t134 VSS__t134 VSS 0.609890529361
* device instance VSS_t135 r0 *1 0,0
RVSS_t135 VSS__t135 VSS 0.594103461898
* device instance VSS_t136 r0 *1 0,0
RVSS_t136 VSS__t136 VSS 0.578316394441
* device instance VSS_t137 r0 *1 0,0
RVSS_t137 VSS__t137 VSS 0.562529326991
* device instance VSS_t138 r0 *1 0,0
RVSS_t138 VSS__t138 VSS 0.546742259548
* device instance VSS_t139 r0 *1 0,0
RVSS_t139 VSS__t139 VSS 0.530955192112
* device instance VSS_t140 r0 *1 0,0
RVSS_t140 VSS__t140 VSS 0.515168124685
* device instance VSS_t141 r0 *1 0,0
RVSS_t141 VSS__t141 VSS 0.751974136731
* device instance VSS_t142 r0 *1 0,0
RVSS_t142 VSS__t142 VSS 0.73618706923
* device instance VSS_t143 r0 *1 0,0
RVSS_t143 VSS__t143 VSS 0.720400001733
* device instance VSS_t144 r0 *1 0,0
RVSS_t144 VSS__t144 VSS 0.704612934239
* device instance VSS_t145 r0 *1 0,0
RVSS_t145 VSS__t145 VSS 0.688825866749
* device instance VSS_t146 r0 *1 0,0
RVSS_t146 VSS__t146 VSS 0.673038799262
* device instance VSS_t147 r0 *1 0,0
RVSS_t147 VSS__t147 VSS 0.65725173178
* device instance VSS_t148 r0 *1 0,0
RVSS_t148 VSS__t148 VSS 0.641464664302
* device instance VSS_t149 r0 *1 0,0
RVSS_t149 VSS__t149 VSS 0.179462867302
* device instance VSS_t150 r0 *1 0,0
RVSS_t150 VSS__t150 VSS 0.98878014951
* device instance VSS_t151 r0 *1 0,0
RVSS_t151 VSS__t151 VSS 0.972993081979
* device instance VSS_t152 r0 *1 0,0
RVSS_t152 VSS__t152 VSS 0.95720601445
* device instance VSS_t153 r0 *1 0,0
RVSS_t153 VSS__t153 VSS 0.941418946922
* device instance VSS_t154 r0 *1 0,0
RVSS_t154 VSS__t154 VSS 0.925631879395
* device instance VSS_t155 r0 *1 0,0
RVSS_t155 VSS__t155 VSS 0.909844811871
* device instance VSS_t156 r0 *1 0,0
RVSS_t156 VSS__t156 VSS 0.894057744347
* device instance VSS_t157 r0 *1 0,0
RVSS_t157 VSS__t157 VSS 0.878270676826
* device instance VSS_t158 r0 *1 0,0
RVSS_t158 VSS__t158 VSS 0.862483609306
* device instance VSS_t159 r0 *1 0,0
RVSS_t159 VSS__t159 VSS 0.846696541789
* device instance VSS_t160 r0 *1 0,0
RVSS_t160 VSS__t160 VSS 0.830909474273
* device instance VSS_t161 r0 *1 0,0
RVSS_t161 VSS__t161 VSS 0.81512240676
* device instance VSS_t162 r0 *1 0,0
RVSS_t162 VSS__t162 VSS 0.799335339249
* device instance VSS_t163 r0 *1 0,0
RVSS_t163 VSS__t163 VSS 0.78354827174
* device instance VSS_t164 r0 *1 0,0
RVSS_t164 VSS__t164 VSS 0.767761204234
* device instance VSS_t165 r0 *1 0,0
RVSS_t165 VSS__t165 VSS 1.00456721704
* device instance VSS_t166 r0 *1 0,0
RVSS_t166 VSS__t166 VSS 0.246787981254
* device instance VSS_t167 r0 *1 0,0
RVSS_t167 VSS__t167 VSS 0.231000914376
* device instance VSS_t168 r0 *1 0,0
RVSS_t168 VSS__t168 VSS 0.2152138476
* device instance VSS_t169 r0 *1 0,0
RVSS_t169 VSS__t169 VSS 0.19942678095
* device instance VSS_t170 r0 *1 0,0
RVSS_t170 VSS__t170 VSS 0.183639714459
* device instance VSS_t171 r0 *1 0,0
RVSS_t171 VSS__t171 VSS 0.16785264817
* device instance VSS_t172 r0 *1 0,0
RVSS_t172 VSS__t172 VSS 0.152065582148
* device instance VSS_t173 r0 *1 0,0
RVSS_t173 VSS__t173 VSS 0.136278516486
* device instance VSS_t174 r0 *1 0,0
RVSS_t174 VSS__t174 VSS 0.120491451323
* device instance VSS_t175 r0 *1 0,0
RVSS_t175 VSS__t175 VSS 0.104704386887
* device instance VSS_t176 r0 *1 0,0
RVSS_t176 VSS__t176 VSS 0.0889173235644
* device instance VSS_t177 r0 *1 0,0
RVSS_t177 VSS__t177 VSS 0.0731302620765
* device instance VSS_t178 r0 *1 0,0
RVSS_t178 VSS__t178 VSS 0.0573432039384
* device instance VSS_t179 r0 *1 0,0
RVSS_t179 VSS__t179 VSS 0.0415561529681
* device instance VSS_t180 r0 *1 0,0
RVSS_t180 VSS__t180 VSS 0.0257691223392
* device instance VSS_t181 r0 *1 0,0
RVSS_t181 VSS__t181 VSS 0.625677596829
* device instance VSS_t182 r0 *1 0,0
RVSS_t182 VSS__t182 VSS 0.262575048216
* device instance VSS_t183 r0 *1 0,0
RVSS_t183 VSS__t183 VSS 0.278362115246
* device instance VSS_t184 r0 *1 0,0
RVSS_t184 VSS__t184 VSS 0.294149182335
* device instance VSS_t185 r0 *1 0,0
RVSS_t185 VSS__t185 VSS 0.309936249473
* device instance VSS_t186 r0 *1 0,0
RVSS_t186 VSS__t186 VSS 0.325723316653
* device instance VSS_t187 r0 *1 0,0
RVSS_t187 VSS__t187 VSS 0.341510383869
* device instance VSS_t188 r0 *1 0,0
RVSS_t188 VSS__t188 VSS 0.357297451116
* device instance VSS_t189 r0 *1 0,0
RVSS_t189 VSS__t189 VSS 0.00998220856247
* device instance VSS_t190 r0 *1 0,0
RVSS_t190 VSS__t190 VSS 0.388871585691
* device instance VSS_t191 r0 *1 0,0
RVSS_t191 VSS__t191 VSS 0.404658653011
* device instance VSS_t192 r0 *1 0,0
RVSS_t192 VSS__t192 VSS 0.42044572035
* device instance VSS_t193 r0 *1 0,0
RVSS_t193 VSS__t193 VSS 0.436232787706
* device instance VSS_t194 r0 *1 0,0
RVSS_t194 VSS__t194 VSS 0.452019855078
* device instance VSS_t195 r0 *1 0,0
RVSS_t195 VSS__t195 VSS 0.467806922462
* device instance VSS_t196 r0 *1 0,0
RVSS_t196 VSS__t196 VSS 0.483593989859
* device instance VSS_t197 r0 *1 0,0
RVSS_t197 VSS__t197 VSS 0.499381057267
* device instance VSS_t198 r0 *1 0,0
RVSS_t198 VSS__t198 VSS 0.373084518391
* device instance VSS_t199 r0 *1 0,0
RVSS_t199 VSS__t199 VSS 0.337333536485
* device instance VSS_t200 r0 *1 0,0
RVSS_t200 VSS__t200 VSS 0.826732626814
* device instance VSS_t201 r0 *1 0,0
RVSS_t201 VSS__t201 VSS 0.353120603725
* device instance VSS_t202 r0 *1 0,0
RVSS_t202 VSS__t202 VSS 0.810945559301
* device instance VSS_t203 r0 *1 0,0
RVSS_t203 VSS__t203 VSS 0.795158491791
* device instance VSS_t204 r0 *1 0,0
RVSS_t204 VSS__t204 VSS 0.779371424283
* device instance VSS_t205 r0 *1 0,0
RVSS_t205 VSS__t205 VSS 0.368907670993
* device instance VSS_t206 r0 *1 0,0
RVSS_t206 VSS__t206 VSS 0.763584356778
* device instance VSS_t207 r0 *1 0,0
RVSS_t207 VSS__t207 VSS 0.984603302046
* device instance VSS_t208 r0 *1 0,0
RVSS_t208 VSS__t208 VSS 0.384694738286
* device instance VSS_t209 r0 *1 0,0
RVSS_t209 VSS__t209 VSS 0.0373793122322
* device instance VSS_t210 r0 *1 0,0
RVSS_t210 VSS__t210 VSS 0.400481805601
* device instance VSS_t211 r0 *1 0,0
RVSS_t211 VSS__t211 VSS 0.416268872936
* device instance VSS_t212 r0 *1 0,0
RVSS_t212 VSS__t212 VSS 0.953029166987
* device instance VSS_t213 r0 *1 0,0
RVSS_t213 VSS__t213 VSS 0.432055940288
* device instance VSS_t214 r0 *1 0,0
RVSS_t214 VSS__t214 VSS 0.447843007655
* device instance VSS_t215 r0 *1 0,0
RVSS_t215 VSS__t215 VSS 0.463630075036
* device instance VSS_t216 r0 *1 0,0
RVSS_t216 VSS__t216 VSS 0.47941714243
* device instance VSS_t217 r0 *1 0,0
RVSS_t217 VSS__t217 VSS 0.93724209946
* device instance VSS_t218 r0 *1 0,0
RVSS_t218 VSS__t218 VSS 0.495204209835
* device instance VSS_t219 r0 *1 0,0
RVSS_t219 VSS__t219 VSS 0.00580554170366
* device instance VSS_t220 r0 *1 0,0
RVSS_t220 VSS__t220 VSS 0.0215922936761
* device instance VSS_t221 r0 *1 0,0
RVSS_t221 VSS__t221 VSS 0.968816234516
* device instance VSS_t222 r0 *1 0,0
RVSS_t222 VSS__t222 VSS 0.668861951812
* device instance VSS_t223 r0 *1 0,0
RVSS_t223 VSS__t223 VSS 0.65307488433
* device instance VSS_t224 r0 *1 0,0
RVSS_t224 VSS__t224 VSS 0.684649019297
* device instance VSS_t225 r0 *1 0,0
RVSS_t225 VSS__t225 VSS 0.700436086786
* device instance VSS_t226 r0 *1 0,0
RVSS_t226 VSS__t226 VSS 0.637287816854
* device instance VSS_t227 r0 *1 0,0
RVSS_t227 VSS__t227 VSS 0.716223154279
* device instance VSS_t228 r0 *1 0,0
RVSS_t228 VSS__t228 VSS 0.732010221776
* device instance VSS_t229 r0 *1 0,0
RVSS_t229 VSS__t229 VSS 0.747797289275
* device instance VSS_t230 r0 *1 0,0
RVSS_t230 VSS__t230 VSS 0.621500749382
* device instance VSS_t231 r0 *1 0,0
RVSS_t231 VSS__t231 VSS 0.258398200896
* device instance VSS_t232 r0 *1 0,0
RVSS_t232 VSS__t232 VSS 0.274185267909
* device instance VSS_t233 r0 *1 0,0
RVSS_t233 VSS__t233 VSS 0.842519694329
* device instance VSS_t234 r0 *1 0,0
RVSS_t234 VSS__t234 VSS 0.589926614454
* device instance VSS_t235 r0 *1 0,0
RVSS_t235 VSS__t235 VSS 0.574139546999
* device instance VSS_t236 r0 *1 0,0
RVSS_t236 VSS__t236 VSS 0.289972334983
* device instance VSS_t237 r0 *1 0,0
RVSS_t237 VSS__t237 VSS 0.55835247955
* device instance VSS_t238 r0 *1 0,0
RVSS_t238 VSS__t238 VSS 0.542565412109
* device instance VSS_t239 r0 *1 0,0
RVSS_t239 VSS__t239 VSS 0.526778344676
* device instance VSS_t240 r0 *1 0,0
RVSS_t240 VSS__t240 VSS 0.305759402109
* device instance VSS_t241 r0 *1 0,0
RVSS_t241 VSS__t241 VSS 0.510991277251
* device instance VSS_t242 r0 *1 0,0
RVSS_t242 VSS__t242 VSS 0.874093829365
* device instance VSS_t243 r0 *1 0,0
RVSS_t243 VSS__t243 VSS 0.858306761846
* device instance VSS_t244 r0 *1 0,0
RVSS_t244 VSS__t244 VSS 0.321546469278
* device instance VSS_t245 r0 *1 0,0
RVSS_t245 VSS__t245 VSS 0.605713681915
* device instance VSS_t246 r0 *1 0,0
RVSS_t246 VSS__t246 VSS 0.0847404774793
* device instance VSS_t247 r0 *1 0,0
RVSS_t247 VSS__t247 VSS 0.921455031934
* device instance VSS_t248 r0 *1 0,0
RVSS_t248 VSS__t248 VSS 0.116314604596
* device instance VSS_t249 r0 *1 0,0
RVSS_t249 VSS__t249 VSS 0.905667964409
* device instance VSS_t250 r0 *1 0,0
RVSS_t250 VSS__t250 VSS 0.068953416678
* device instance VSS_t251 r0 *1 0,0
RVSS_t251 VSS__t251 VSS 0.132101669593
* device instance VSS_t252 r0 *1 0,0
RVSS_t252 VSS__t252 VSS 0.14788873514
* device instance VSS_t253 r0 *1 0,0
RVSS_t253 VSS__t253 VSS 0.0531663598974
* device instance VSS_t254 r0 *1 0,0
RVSS_t254 VSS__t254 VSS 0.100527540407
* device instance VSS_t255 r0 *1 0,0
RVSS_t255 VSS__t255 VSS 0.889880896886
* device instance VSS_t256 r0 *1 0,0
RVSS_t256 VSS__t256 VSS 1.00761136757
* device instance VSS_t257 r0 *1 0,0
RVSS_t257 VSS__t257 VSS 0.991824300156
* device instance VSS_t258 r0 *1 0,0
RVSS_t258 VSS__t258 VSS 0.976037232748
* device instance VSS_t259 r0 *1 0,0
RVSS_t259 VSS__t259 VSS 0.960250165345
* device instance VSS_t260 r0 *1 0,0
RVSS_t260 VSS__t260 VSS 0.944463097947
* device instance VSS_t261 r0 *1 0,0
RVSS_t261 VSS__t261 VSS 0.928676030556
* device instance VSS_t262 r0 *1 0,0
RVSS_t262 VSS__t262 VSS 0.912888963171
* device instance VSS_t263 r0 *1 0,0
RVSS_t263 VSS__t263 VSS 0.897101895792
* device instance VSS_t264 r0 *1 0,0
RVSS_t264 VSS__t264 VSS 0.881314828421
* device instance VSS_t265 r0 *1 0,0
RVSS_t265 VSS__t265 VSS 0.865527761056
* device instance VSS_t266 r0 *1 0,0
RVSS_t266 VSS__t266 VSS 0.8497406937
* device instance VSS_t267 r0 *1 0,0
RVSS_t267 VSS__t267 VSS 0.833953626351
* device instance VSS_t268 r0 *1 0,0
RVSS_t268 VSS__t268 VSS 0.818166559011
* device instance VSS_t269 r0 *1 0,0
RVSS_t269 VSS__t269 VSS 0.80237949168
* device instance VSS_t270 r0 *1 0,0
RVSS_t270 VSS__t270 VSS 0.786592424359
* device instance VSS_t271 r0 *1 0,0
RVSS_t271 VSS__t271 VSS 0.770805357048
* device instance VSS_t272 r0 *1 0,0
RVSS_t272 VSS__t272 VSS 0.755018289749
* device instance VSS_t273 r0 *1 0,0
RVSS_t273 VSS__t273 VSS 0.73923122246
* device instance VSS_t274 r0 *1 0,0
RVSS_t274 VSS__t274 VSS 0.723444155184
* device instance VSS_t275 r0 *1 0,0
RVSS_t275 VSS__t275 VSS 0.707657087922
* device instance VSS_t276 r0 *1 0,0
RVSS_t276 VSS__t276 VSS 0.691870020673
* device instance VSS_t277 r0 *1 0,0
RVSS_t277 VSS__t277 VSS 0.67608295344
* device instance VSS_t278 r0 *1 0,0
RVSS_t278 VSS__t278 VSS 0.660295886222
* device instance VSS_t279 r0 *1 0,0
RVSS_t279 VSS__t279 VSS 0.644508819022
* device instance VSS_t280 r0 *1 0,0
RVSS_t280 VSS__t280 VSS 0.628721751841
* device instance VSS_t281 r0 *1 0,0
RVSS_t281 VSS__t281 VSS 0.61293468468
* device instance VSS_t282 r0 *1 0,0
RVSS_t282 VSS__t282 VSS 0.59714761754
* device instance VSS_t283 r0 *1 0,0
RVSS_t283 VSS__t283 VSS 0.581360550424
* device instance VSS_t284 r0 *1 0,0
RVSS_t284 VSS__t284 VSS 0.565573483334
* device instance VSS_t285 r0 *1 0,0
RVSS_t285 VSS__t285 VSS 0.549786416271
* device instance VSS_t286 r0 *1 0,0
RVSS_t286 VSS__t286 VSS 0.533999349238
* device instance VSS_t287 r0 *1 0,0
RVSS_t287 VSS__t287 VSS 0.518212282238
* device instance VSS_t288 r0 *1 0,0
RVSS_t288 VSS__t288 VSS 0.502425215274
* device instance VSS_t289 r0 *1 0,0
RVSS_t289 VSS__t289 VSS 0.486638148349
* device instance VSS_t290 r0 *1 0,0
RVSS_t290 VSS__t290 VSS 0.470851081468
* device instance VSS_t291 r0 *1 0,0
RVSS_t291 VSS__t291 VSS 0.455064014635
* device instance VSS_t292 r0 *1 0,0
RVSS_t292 VSS__t292 VSS 0.439276947855
* device instance VSS_t293 r0 *1 0,0
RVSS_t293 VSS__t293 VSS 0.423489881134
* device instance VSS_t294 r0 *1 0,0
RVSS_t294 VSS__t294 VSS 0.407702814478
* device instance VSS_t295 r0 *1 0,0
RVSS_t295 VSS__t295 VSS 0.391915747897
* device instance VSS_t296 r0 *1 0,0
RVSS_t296 VSS__t296 VSS 0.376128681398
* device instance VSS_t297 r0 *1 0,0
RVSS_t297 VSS__t297 VSS 0.360341614994
* device instance VSS_t298 r0 *1 0,0
RVSS_t298 VSS__t298 VSS 0.344554548697
* device instance VSS_t299 r0 *1 0,0
RVSS_t299 VSS__t299 VSS 0.328767482522
* device instance VSS_t300 r0 *1 0,0
RVSS_t300 VSS__t300 VSS 0.312980416488
* device instance VSS_t301 r0 *1 0,0
RVSS_t301 VSS__t301 VSS 0.297193350618
* device instance VSS_t302 r0 *1 0,0
RVSS_t302 VSS__t302 VSS 0.281406284938
* device instance VSS_t303 r0 *1 0,0
RVSS_t303 VSS__t303 VSS 0.265619219483
* device instance VSS_t304 r0 *1 0,0
RVSS_t304 VSS__t304 VSS 0.249832154296
* device instance VSS_t305 r0 *1 0,0
RVSS_t305 VSS__t305 VSS 0.23404508943
* device instance VSS_t306 r0 *1 0,0
RVSS_t306 VSS__t306 VSS 0.218258024956
* device instance VSS_t307 r0 *1 0,0
RVSS_t307 VSS__t307 VSS 0.202470960965
* device instance VSS_t308 r0 *1 0,0
RVSS_t308 VSS__t308 VSS 0.18668389758
* device instance VSS_t309 r0 *1 0,0
RVSS_t309 VSS__t309 VSS 0.170896834968
* device instance VSS_t310 r0 *1 0,0
RVSS_t310 VSS__t310 VSS 0.155109773366
* device instance VSS_t311 r0 *1 0,0
RVSS_t311 VSS__t311 VSS 0.139322713117
* device instance VSS_t312 r0 *1 0,0
RVSS_t312 VSS__t312 VSS 0.123535654739
* device instance VSS_t313 r0 *1 0,0
RVSS_t313 VSS__t313 VSS 0.107748599056
* device instance VSS_t314 r0 *1 0,0
RVSS_t314 VSS__t314 VSS 0.0919615474541
* device instance VSS_t315 r0 *1 0,0
RVSS_t315 VSS__t315 VSS 0.0761745024719
* device instance VSS_t316 r0 *1 0,0
RVSS_t316 VSS__t316 VSS 0.0603874693009
* device instance VSS_t317 r0 *1 0,0
RVSS_t317 VSS__t317 VSS 0.0446004604834
* device instance VSS_t318 r0 *1 0,0
RVSS_t318 VSS__t318 VSS 0.0288135160493
* device instance VSS_t319 r0 *1 0,0
RVSS_t319 VSS__t319 VSS 0.0130268700749
* device instance VSS_t320 r0 *1 0,0
RVSS_t320 VSS__t320 VSS 0.0027645950535
* device instance VSS_t321 r0 *1 0,0
RVSS_t321 VSS__t321 VSS 0.0185485749508
* device instance VSS_t322 r0 *1 0,0
RVSS_t322 VSS__t322 VSS 0.034335394051
* device instance VSS_t323 r0 *1 0,0
RVSS_t323 VSS__t323 VSS 0.0501223696726
* device instance VSS_t324 r0 *1 0,0
RVSS_t324 VSS__t324 VSS 0.0659093893432
* device instance VSS_t325 r0 *1 0,0
RVSS_t325 VSS__t325 VSS 0.0816964275267
* device instance VSS_t326 r0 *1 0,0
RVSS_t326 VSS__t326 VSS 0.0974834752288
* device instance VSS_t327 r0 *1 0,0
RVSS_t327 VSS__t327 VSS 0.11327052847
* device instance VSS_t328 r0 *1 0,0
RVSS_t328 VSS__t328 VSS 0.129057585217
* device instance VSS_t329 r0 *1 0,0
RVSS_t329 VSS__t329 VSS 0.144844644323
* device instance VSS_t330 r0 *1 0,0
RVSS_t330 VSS__t330 VSS 0.160631705094
* device instance VSS_t331 r0 *1 0,0
RVSS_t331 VSS__t331 VSS 0.176418767081
* device instance VSS_t332 r0 *1 0,0
RVSS_t332 VSS__t332 VSS 0.192205829986
* device instance VSS_t333 r0 *1 0,0
RVSS_t333 VSS__t333 VSS 0.2079928936
* device instance VSS_t334 r0 *1 0,0
RVSS_t334 VSS__t334 VSS 0.223779957772
* device instance VSS_t335 r0 *1 0,0
RVSS_t335 VSS__t335 VSS 0.239567022392
* device instance VSS_t336 r0 *1 0,0
RVSS_t336 VSS__t336 VSS 0.255354087377
* device instance VSS_t337 r0 *1 0,0
RVSS_t337 VSS__t337 VSS 0.271141152663
* device instance VSS_t338 r0 *1 0,0
RVSS_t338 VSS__t338 VSS 0.286928218201
* device instance VSS_t339 r0 *1 0,0
RVSS_t339 VSS__t339 VSS 0.302715283951
* device instance VSS_t340 r0 *1 0,0
RVSS_t340 VSS__t340 VSS 0.318502349882
* device instance VSS_t341 r0 *1 0,0
RVSS_t341 VSS__t341 VSS 0.334289415967
* device instance VSS_t342 r0 *1 0,0
RVSS_t342 VSS__t342 VSS 0.350076482187
* device instance VSS_t343 r0 *1 0,0
RVSS_t343 VSS__t343 VSS 0.365863548523
* device instance VSS_t344 r0 *1 0,0
RVSS_t344 VSS__t344 VSS 0.381650614962
* device instance VSS_t345 r0 *1 0,0
RVSS_t345 VSS__t345 VSS 0.39743768149
* device instance VSS_t346 r0 *1 0,0
RVSS_t346 VSS__t346 VSS 0.413224748099
* device instance VSS_t347 r0 *1 0,0
RVSS_t347 VSS__t347 VSS 0.429011814778
* device instance VSS_t348 r0 *1 0,0
RVSS_t348 VSS__t348 VSS 0.44479888152
* device instance VSS_t349 r0 *1 0,0
RVSS_t349 VSS__t349 VSS 0.46058594832
* device instance VSS_t350 r0 *1 0,0
RVSS_t350 VSS__t350 VSS 0.47637301517
* device instance VSS_t351 r0 *1 0,0
RVSS_t351 VSS__t351 VSS 0.492160082067
* device instance VSS_t352 r0 *1 0,0
RVSS_t352 VSS__t352 VSS 0.507947149006
* device instance VSS_t353 r0 *1 0,0
RVSS_t353 VSS__t353 VSS 0.523734215983
* device instance VSS_t354 r0 *1 0,0
RVSS_t354 VSS__t354 VSS 0.539521282995
* device instance VSS_t355 r0 *1 0,0
RVSS_t355 VSS__t355 VSS 0.555308350038
* device instance VSS_t356 r0 *1 0,0
RVSS_t356 VSS__t356 VSS 0.571095417111
* device instance VSS_t357 r0 *1 0,0
RVSS_t357 VSS__t357 VSS 0.586882484211
* device instance VSS_t358 r0 *1 0,0
RVSS_t358 VSS__t358 VSS 0.602669551335
* device instance VSS_t359 r0 *1 0,0
RVSS_t359 VSS__t359 VSS 0.618456618483
* device instance VSS_t360 r0 *1 0,0
RVSS_t360 VSS__t360 VSS 0.634243685651
* device instance VSS_t361 r0 *1 0,0
RVSS_t361 VSS__t361 VSS 0.650030752839
* device instance VSS_t362 r0 *1 0,0
RVSS_t362 VSS__t362 VSS 0.665817820045
* device instance VSS_t363 r0 *1 0,0
RVSS_t363 VSS__t363 VSS 0.681604887268
* device instance VSS_t364 r0 *1 0,0
RVSS_t364 VSS__t364 VSS 0.697391954507
* device instance VSS_t365 r0 *1 0,0
RVSS_t365 VSS__t365 VSS 0.713179021761
* device instance VSS_t366 r0 *1 0,0
RVSS_t366 VSS__t366 VSS 0.728966089028
* device instance VSS_t367 r0 *1 0,0
RVSS_t367 VSS__t367 VSS 0.744753156309
* device instance VSS_t368 r0 *1 0,0
RVSS_t368 VSS__t368 VSS 0.760540223601
* device instance VSS_t369 r0 *1 0,0
RVSS_t369 VSS__t369 VSS 0.776327290905
* device instance VSS_t370 r0 *1 0,0
RVSS_t370 VSS__t370 VSS 0.792114358219
* device instance VSS_t371 r0 *1 0,0
RVSS_t371 VSS__t371 VSS 0.807901425544
* device instance VSS_t372 r0 *1 0,0
RVSS_t372 VSS__t372 VSS 0.823688492878
* device instance VSS_t373 r0 *1 0,0
RVSS_t373 VSS__t373 VSS 0.839475560221
* device instance VSS_t374 r0 *1 0,0
RVSS_t374 VSS__t374 VSS 0.855262627572
* device instance VSS_t375 r0 *1 0,0
RVSS_t375 VSS__t375 VSS 0.871049694932
* device instance VSS_t376 r0 *1 0,0
RVSS_t376 VSS__t376 VSS 0.886836762299
* device instance VSS_t377 r0 *1 0,0
RVSS_t377 VSS__t377 VSS 0.902623829673
* device instance VSS_t378 r0 *1 0,0
RVSS_t378 VSS__t378 VSS 0.918410897054
* device instance VSS_t379 r0 *1 0,0
RVSS_t379 VSS__t379 VSS 0.934197964441
* device instance VSS_t380 r0 *1 0,0
RVSS_t380 VSS__t380 VSS 0.949985031835
* device instance VSS_t381 r0 *1 0,0
RVSS_t381 VSS__t381 VSS 0.965772099234
* device instance VSS_t382 r0 *1 0,0
RVSS_t382 VSS__t382 VSS 0.981559166639
* device instance VSS_t383 r0 *1 0,0
RVSS_t383 VSS__t383 VSS 0.997346234049
* device instance VSS_t384 r0 *1 0,0
RVSS_t384 VSS__t384 VSS 0.997346234049
* device instance VSS_t385 r0 *1 0,0
RVSS_t385 VSS__t385 VSS 0.981559166639
* device instance VSS_t386 r0 *1 0,0
RVSS_t386 VSS__t386 VSS 0.965772099234
* device instance VSS_t387 r0 *1 0,0
RVSS_t387 VSS__t387 VSS 0.949985031835
* device instance VSS_t388 r0 *1 0,0
RVSS_t388 VSS__t388 VSS 0.934197964441
* device instance VSS_t389 r0 *1 0,0
RVSS_t389 VSS__t389 VSS 0.918410897054
* device instance VSS_t390 r0 *1 0,0
RVSS_t390 VSS__t390 VSS 0.902623829673
* device instance VSS_t391 r0 *1 0,0
RVSS_t391 VSS__t391 VSS 0.886836762299
* device instance VSS_t392 r0 *1 0,0
RVSS_t392 VSS__t392 VSS 0.871049694932
* device instance VSS_t393 r0 *1 0,0
RVSS_t393 VSS__t393 VSS 0.855262627572
* device instance VSS_t394 r0 *1 0,0
RVSS_t394 VSS__t394 VSS 0.839475560221
* device instance VSS_t395 r0 *1 0,0
RVSS_t395 VSS__t395 VSS 0.823688492878
* device instance VSS_t396 r0 *1 0,0
RVSS_t396 VSS__t396 VSS 0.807901425544
* device instance VSS_t397 r0 *1 0,0
RVSS_t397 VSS__t397 VSS 0.792114358219
* device instance VSS_t398 r0 *1 0,0
RVSS_t398 VSS__t398 VSS 0.776327290905
* device instance VSS_t399 r0 *1 0,0
RVSS_t399 VSS__t399 VSS 0.760540223601
* device instance VSS_t400 r0 *1 0,0
RVSS_t400 VSS__t400 VSS 0.744753156309
* device instance VSS_t401 r0 *1 0,0
RVSS_t401 VSS__t401 VSS 0.728966089028
* device instance VSS_t402 r0 *1 0,0
RVSS_t402 VSS__t402 VSS 0.713179021761
* device instance VSS_t403 r0 *1 0,0
RVSS_t403 VSS__t403 VSS 0.697391954507
* device instance VSS_t404 r0 *1 0,0
RVSS_t404 VSS__t404 VSS 0.681604887268
* device instance VSS_t405 r0 *1 0,0
RVSS_t405 VSS__t405 VSS 0.665817820045
* device instance VSS_t406 r0 *1 0,0
RVSS_t406 VSS__t406 VSS 0.650030752839
* device instance VSS_t407 r0 *1 0,0
RVSS_t407 VSS__t407 VSS 0.634243685651
* device instance VSS_t408 r0 *1 0,0
RVSS_t408 VSS__t408 VSS 0.618456618483
* device instance VSS_t409 r0 *1 0,0
RVSS_t409 VSS__t409 VSS 0.602669551335
* device instance VSS_t410 r0 *1 0,0
RVSS_t410 VSS__t410 VSS 0.586882484211
* device instance VSS_t411 r0 *1 0,0
RVSS_t411 VSS__t411 VSS 0.571095417111
* device instance VSS_t412 r0 *1 0,0
RVSS_t412 VSS__t412 VSS 0.555308350038
* device instance VSS_t413 r0 *1 0,0
RVSS_t413 VSS__t413 VSS 0.539521282995
* device instance VSS_t414 r0 *1 0,0
RVSS_t414 VSS__t414 VSS 0.523734215983
* device instance VSS_t415 r0 *1 0,0
RVSS_t415 VSS__t415 VSS 0.507947149006
* device instance VSS_t416 r0 *1 0,0
RVSS_t416 VSS__t416 VSS 0.492160082067
* device instance VSS_t417 r0 *1 0,0
RVSS_t417 VSS__t417 VSS 0.47637301517
* device instance VSS_t418 r0 *1 0,0
RVSS_t418 VSS__t418 VSS 0.46058594832
* device instance VSS_t419 r0 *1 0,0
RVSS_t419 VSS__t419 VSS 0.44479888152
* device instance VSS_t420 r0 *1 0,0
RVSS_t420 VSS__t420 VSS 0.429011814778
* device instance VSS_t421 r0 *1 0,0
RVSS_t421 VSS__t421 VSS 0.413224748099
* device instance VSS_t422 r0 *1 0,0
RVSS_t422 VSS__t422 VSS 0.39743768149
* device instance VSS_t423 r0 *1 0,0
RVSS_t423 VSS__t423 VSS 0.381650614962
* device instance VSS_t424 r0 *1 0,0
RVSS_t424 VSS__t424 VSS 0.365863548523
* device instance VSS_t425 r0 *1 0,0
RVSS_t425 VSS__t425 VSS 0.350076482187
* device instance VSS_t426 r0 *1 0,0
RVSS_t426 VSS__t426 VSS 0.334289415967
* device instance VSS_t427 r0 *1 0,0
RVSS_t427 VSS__t427 VSS 0.318502349882
* device instance VSS_t428 r0 *1 0,0
RVSS_t428 VSS__t428 VSS 0.302715283951
* device instance VSS_t429 r0 *1 0,0
RVSS_t429 VSS__t429 VSS 0.286928218201
* device instance VSS_t430 r0 *1 0,0
RVSS_t430 VSS__t430 VSS 0.271141152663
* device instance VSS_t431 r0 *1 0,0
RVSS_t431 VSS__t431 VSS 0.255354087377
* device instance VSS_t432 r0 *1 0,0
RVSS_t432 VSS__t432 VSS 0.239567022392
* device instance VSS_t433 r0 *1 0,0
RVSS_t433 VSS__t433 VSS 0.223779957772
* device instance VSS_t434 r0 *1 0,0
RVSS_t434 VSS__t434 VSS 0.2079928936
* device instance VSS_t435 r0 *1 0,0
RVSS_t435 VSS__t435 VSS 0.192205829986
* device instance VSS_t436 r0 *1 0,0
RVSS_t436 VSS__t436 VSS 0.176418767081
* device instance VSS_t437 r0 *1 0,0
RVSS_t437 VSS__t437 VSS 0.160631705094
* device instance VSS_t438 r0 *1 0,0
RVSS_t438 VSS__t438 VSS 0.144844644323
* device instance VSS_t439 r0 *1 0,0
RVSS_t439 VSS__t439 VSS 0.129057585217
* device instance VSS_t440 r0 *1 0,0
RVSS_t440 VSS__t440 VSS 0.11327052847
* device instance VSS_t441 r0 *1 0,0
RVSS_t441 VSS__t441 VSS 0.0974834752288
* device instance VSS_t442 r0 *1 0,0
RVSS_t442 VSS__t442 VSS 0.0816964275267
* device instance VSS_t443 r0 *1 0,0
RVSS_t443 VSS__t443 VSS 0.0659093893432
* device instance VSS_t444 r0 *1 0,0
RVSS_t444 VSS__t444 VSS 0.0501223696726
* device instance VSS_t445 r0 *1 0,0
RVSS_t445 VSS__t445 VSS 0.034335394051
* device instance VSS_t446 r0 *1 0,0
RVSS_t446 VSS__t446 VSS 0.0185485749508
* device instance VSS_t447 r0 *1 0,0
RVSS_t447 VSS__t447 VSS 0.0027645950535
* device instance VSS_t448 r0 *1 0,0
RVSS_t448 VSS__t448 VSS 0.0130268700749
* device instance VSS_t449 r0 *1 0,0
RVSS_t449 VSS__t449 VSS 0.0288135160493
* device instance VSS_t450 r0 *1 0,0
RVSS_t450 VSS__t450 VSS 0.0446004604834
* device instance VSS_t451 r0 *1 0,0
RVSS_t451 VSS__t451 VSS 0.0603874693009
* device instance VSS_t452 r0 *1 0,0
RVSS_t452 VSS__t452 VSS 0.0761745024719
* device instance VSS_t453 r0 *1 0,0
RVSS_t453 VSS__t453 VSS 0.0919615474541
* device instance VSS_t454 r0 *1 0,0
RVSS_t454 VSS__t454 VSS 0.107748599056
* device instance VSS_t455 r0 *1 0,0
RVSS_t455 VSS__t455 VSS 0.123535654739
* device instance VSS_t456 r0 *1 0,0
RVSS_t456 VSS__t456 VSS 0.139322713117
* device instance VSS_t457 r0 *1 0,0
RVSS_t457 VSS__t457 VSS 0.155109773366
* device instance VSS_t458 r0 *1 0,0
RVSS_t458 VSS__t458 VSS 0.170896834968
* device instance VSS_t459 r0 *1 0,0
RVSS_t459 VSS__t459 VSS 0.18668389758
* device instance VSS_t460 r0 *1 0,0
RVSS_t460 VSS__t460 VSS 0.202470960965
* device instance VSS_t461 r0 *1 0,0
RVSS_t461 VSS__t461 VSS 0.218258024956
* device instance VSS_t462 r0 *1 0,0
RVSS_t462 VSS__t462 VSS 0.23404508943
* device instance VSS_t463 r0 *1 0,0
RVSS_t463 VSS__t463 VSS 0.249832154296
* device instance VSS_t464 r0 *1 0,0
RVSS_t464 VSS__t464 VSS 0.265619219483
* device instance VSS_t465 r0 *1 0,0
RVSS_t465 VSS__t465 VSS 0.281406284938
* device instance VSS_t466 r0 *1 0,0
RVSS_t466 VSS__t466 VSS 0.297193350618
* device instance VSS_t467 r0 *1 0,0
RVSS_t467 VSS__t467 VSS 0.312980416488
* device instance VSS_t468 r0 *1 0,0
RVSS_t468 VSS__t468 VSS 0.328767482522
* device instance VSS_t469 r0 *1 0,0
RVSS_t469 VSS__t469 VSS 0.344554548697
* device instance VSS_t470 r0 *1 0,0
RVSS_t470 VSS__t470 VSS 0.360341614994
* device instance VSS_t471 r0 *1 0,0
RVSS_t471 VSS__t471 VSS 0.376128681398
* device instance VSS_t472 r0 *1 0,0
RVSS_t472 VSS__t472 VSS 0.391915747897
* device instance VSS_t473 r0 *1 0,0
RVSS_t473 VSS__t473 VSS 0.407702814478
* device instance VSS_t474 r0 *1 0,0
RVSS_t474 VSS__t474 VSS 0.423489881134
* device instance VSS_t475 r0 *1 0,0
RVSS_t475 VSS__t475 VSS 0.439276947855
* device instance VSS_t476 r0 *1 0,0
RVSS_t476 VSS__t476 VSS 0.455064014635
* device instance VSS_t477 r0 *1 0,0
RVSS_t477 VSS__t477 VSS 0.470851081468
* device instance VSS_t478 r0 *1 0,0
RVSS_t478 VSS__t478 VSS 0.486638148349
* device instance VSS_t479 r0 *1 0,0
RVSS_t479 VSS__t479 VSS 0.502425215274
* device instance VSS_t480 r0 *1 0,0
RVSS_t480 VSS__t480 VSS 0.518212282238
* device instance VSS_t481 r0 *1 0,0
RVSS_t481 VSS__t481 VSS 0.533999349238
* device instance VSS_t482 r0 *1 0,0
RVSS_t482 VSS__t482 VSS 0.549786416271
* device instance VSS_t483 r0 *1 0,0
RVSS_t483 VSS__t483 VSS 0.565573483334
* device instance VSS_t484 r0 *1 0,0
RVSS_t484 VSS__t484 VSS 0.581360550424
* device instance VSS_t485 r0 *1 0,0
RVSS_t485 VSS__t485 VSS 0.59714761754
* device instance VSS_t486 r0 *1 0,0
RVSS_t486 VSS__t486 VSS 0.61293468468
* device instance VSS_t487 r0 *1 0,0
RVSS_t487 VSS__t487 VSS 0.628721751841
* device instance VSS_t488 r0 *1 0,0
RVSS_t488 VSS__t488 VSS 0.644508819022
* device instance VSS_t489 r0 *1 0,0
RVSS_t489 VSS__t489 VSS 0.660295886222
* device instance VSS_t490 r0 *1 0,0
RVSS_t490 VSS__t490 VSS 0.67608295344
* device instance VSS_t491 r0 *1 0,0
RVSS_t491 VSS__t491 VSS 0.691870020673
* device instance VSS_t492 r0 *1 0,0
RVSS_t492 VSS__t492 VSS 0.707657087922
* device instance VSS_t493 r0 *1 0,0
RVSS_t493 VSS__t493 VSS 0.723444155184
* device instance VSS_t494 r0 *1 0,0
RVSS_t494 VSS__t494 VSS 0.73923122246
* device instance VSS_t495 r0 *1 0,0
RVSS_t495 VSS__t495 VSS 0.755018289749
* device instance VSS_t496 r0 *1 0,0
RVSS_t496 VSS__t496 VSS 0.770805357048
* device instance VSS_t497 r0 *1 0,0
RVSS_t497 VSS__t497 VSS 0.786592424359
* device instance VSS_t498 r0 *1 0,0
RVSS_t498 VSS__t498 VSS 0.80237949168
* device instance VSS_t499 r0 *1 0,0
RVSS_t499 VSS__t499 VSS 0.818166559011
* device instance VSS_t500 r0 *1 0,0
RVSS_t500 VSS__t500 VSS 0.833953626351
* device instance VSS_t501 r0 *1 0,0
RVSS_t501 VSS__t501 VSS 0.8497406937
* device instance VSS_t502 r0 *1 0,0
RVSS_t502 VSS__t502 VSS 0.865527761056
* device instance VSS_t503 r0 *1 0,0
RVSS_t503 VSS__t503 VSS 0.881314828421
* device instance VSS_t504 r0 *1 0,0
RVSS_t504 VSS__t504 VSS 0.897101895792
* device instance VSS_t505 r0 *1 0,0
RVSS_t505 VSS__t505 VSS 0.912888963171
* device instance VSS_t506 r0 *1 0,0
RVSS_t506 VSS__t506 VSS 0.928676030556
* device instance VSS_t507 r0 *1 0,0
RVSS_t507 VSS__t507 VSS 0.944463097947
* device instance VSS_t508 r0 *1 0,0
RVSS_t508 VSS__t508 VSS 0.960250165345
* device instance VSS_t509 r0 *1 0,0
RVSS_t509 VSS__t509 VSS 0.976037232748
* device instance VSS_t510 r0 *1 0,0
RVSS_t510 VSS__t510 VSS 0.991824300156
* device instance VSS_t511 r0 *1 0,0
RVSS_t511 VSS__t511 VSS 1.00761136757
* device instance VSS_t512 r0 *1 0,0
RVSS_t512 VSS__t512 VSS 1.00456721704
* device instance VSS_t513 r0 *1 0,0
RVSS_t513 VSS__t513 VSS 0.98878014951
* device instance VSS_t514 r0 *1 0,0
RVSS_t514 VSS__t514 VSS 0.972993081979
* device instance VSS_t515 r0 *1 0,0
RVSS_t515 VSS__t515 VSS 0.95720601445
* device instance VSS_t516 r0 *1 0,0
RVSS_t516 VSS__t516 VSS 0.941418946922
* device instance VSS_t517 r0 *1 0,0
RVSS_t517 VSS__t517 VSS 0.925631879395
* device instance VSS_t518 r0 *1 0,0
RVSS_t518 VSS__t518 VSS 0.909844811871
* device instance VSS_t519 r0 *1 0,0
RVSS_t519 VSS__t519 VSS 0.894057744347
* device instance VSS_t520 r0 *1 0,0
RVSS_t520 VSS__t520 VSS 0.878270676826
* device instance VSS_t521 r0 *1 0,0
RVSS_t521 VSS__t521 VSS 0.862483609306
* device instance VSS_t522 r0 *1 0,0
RVSS_t522 VSS__t522 VSS 0.846696541789
* device instance VSS_t523 r0 *1 0,0
RVSS_t523 VSS__t523 VSS 0.830909474273
* device instance VSS_t524 r0 *1 0,0
RVSS_t524 VSS__t524 VSS 0.81512240676
* device instance VSS_t525 r0 *1 0,0
RVSS_t525 VSS__t525 VSS 0.799335339249
* device instance VSS_t526 r0 *1 0,0
RVSS_t526 VSS__t526 VSS 0.78354827174
* device instance VSS_t527 r0 *1 0,0
RVSS_t527 VSS__t527 VSS 0.767761204234
* device instance VSS_t528 r0 *1 0,0
RVSS_t528 VSS__t528 VSS 0.751974136731
* device instance VSS_t529 r0 *1 0,0
RVSS_t529 VSS__t529 VSS 0.73618706923
* device instance VSS_t530 r0 *1 0,0
RVSS_t530 VSS__t530 VSS 0.720400001733
* device instance VSS_t531 r0 *1 0,0
RVSS_t531 VSS__t531 VSS 0.704612934239
* device instance VSS_t532 r0 *1 0,0
RVSS_t532 VSS__t532 VSS 0.688825866749
* device instance VSS_t533 r0 *1 0,0
RVSS_t533 VSS__t533 VSS 0.673038799262
* device instance VSS_t534 r0 *1 0,0
RVSS_t534 VSS__t534 VSS 0.65725173178
* device instance VSS_t535 r0 *1 0,0
RVSS_t535 VSS__t535 VSS 0.641464664302
* device instance VSS_t536 r0 *1 0,0
RVSS_t536 VSS__t536 VSS 0.625677596829
* device instance VSS_t537 r0 *1 0,0
RVSS_t537 VSS__t537 VSS 0.609890529361
* device instance VSS_t538 r0 *1 0,0
RVSS_t538 VSS__t538 VSS 0.594103461898
* device instance VSS_t539 r0 *1 0,0
RVSS_t539 VSS__t539 VSS 0.578316394441
* device instance VSS_t540 r0 *1 0,0
RVSS_t540 VSS__t540 VSS 0.562529326991
* device instance VSS_t541 r0 *1 0,0
RVSS_t541 VSS__t541 VSS 0.546742259548
* device instance VSS_t542 r0 *1 0,0
RVSS_t542 VSS__t542 VSS 0.530955192112
* device instance VSS_t543 r0 *1 0,0
RVSS_t543 VSS__t543 VSS 0.515168124685
* device instance VSS_t544 r0 *1 0,0
RVSS_t544 VSS__t544 VSS 0.499381057267
* device instance VSS_t545 r0 *1 0,0
RVSS_t545 VSS__t545 VSS 0.483593989859
* device instance VSS_t546 r0 *1 0,0
RVSS_t546 VSS__t546 VSS 0.467806922462
* device instance VSS_t547 r0 *1 0,0
RVSS_t547 VSS__t547 VSS 0.452019855078
* device instance VSS_t548 r0 *1 0,0
RVSS_t548 VSS__t548 VSS 0.436232787706
* device instance VSS_t549 r0 *1 0,0
RVSS_t549 VSS__t549 VSS 0.42044572035
* device instance VSS_t550 r0 *1 0,0
RVSS_t550 VSS__t550 VSS 0.404658653011
* device instance VSS_t551 r0 *1 0,0
RVSS_t551 VSS__t551 VSS 0.388871585691
* device instance VSS_t552 r0 *1 0,0
RVSS_t552 VSS__t552 VSS 0.373084518391
* device instance VSS_t553 r0 *1 0,0
RVSS_t553 VSS__t553 VSS 0.357297451116
* device instance VSS_t554 r0 *1 0,0
RVSS_t554 VSS__t554 VSS 0.341510383869
* device instance VSS_t555 r0 *1 0,0
RVSS_t555 VSS__t555 VSS 0.325723316653
* device instance VSS_t556 r0 *1 0,0
RVSS_t556 VSS__t556 VSS 0.309936249473
* device instance VSS_t557 r0 *1 0,0
RVSS_t557 VSS__t557 VSS 0.294149182335
* device instance VSS_t558 r0 *1 0,0
RVSS_t558 VSS__t558 VSS 0.278362115246
* device instance VSS_t559 r0 *1 0,0
RVSS_t559 VSS__t559 VSS 0.262575048216
* device instance VSS_t560 r0 *1 0,0
RVSS_t560 VSS__t560 VSS 0.246787981254
* device instance VSS_t561 r0 *1 0,0
RVSS_t561 VSS__t561 VSS 0.231000914376
* device instance VSS_t562 r0 *1 0,0
RVSS_t562 VSS__t562 VSS 0.2152138476
* device instance VSS_t563 r0 *1 0,0
RVSS_t563 VSS__t563 VSS 0.19942678095
* device instance VSS_t564 r0 *1 0,0
RVSS_t564 VSS__t564 VSS 0.183639714459
* device instance VSS_t565 r0 *1 0,0
RVSS_t565 VSS__t565 VSS 0.16785264817
* device instance VSS_t566 r0 *1 0,0
RVSS_t566 VSS__t566 VSS 0.152065582148
* device instance VSS_t567 r0 *1 0,0
RVSS_t567 VSS__t567 VSS 0.136278516486
* device instance VSS_t568 r0 *1 0,0
RVSS_t568 VSS__t568 VSS 0.120491451323
* device instance VSS_t569 r0 *1 0,0
RVSS_t569 VSS__t569 VSS 0.104704386887
* device instance VSS_t570 r0 *1 0,0
RVSS_t570 VSS__t570 VSS 0.0889173235644
* device instance VSS_t571 r0 *1 0,0
RVSS_t571 VSS__t571 VSS 0.0731302620765
* device instance VSS_t572 r0 *1 0,0
RVSS_t572 VSS__t572 VSS 0.0573432039384
* device instance VSS_t573 r0 *1 0,0
RVSS_t573 VSS__t573 VSS 0.0415561529681
* device instance VSS_t574 r0 *1 0,0
RVSS_t574 VSS__t574 VSS 0.0257691223392
* device instance VSS_t575 r0 *1 0,0
RVSS_t575 VSS__t575 VSS 0.00998220856247
* device instance VSS_t576 r0 *1 0,0
RVSS_t576 VSS__t576 VSS 0.00580554170366
* device instance VSS_t577 r0 *1 0,0
RVSS_t577 VSS__t577 VSS 0.0215922936761
* device instance VSS_t578 r0 *1 0,0
RVSS_t578 VSS__t578 VSS 0.0373793122322
* device instance VSS_t579 r0 *1 0,0
RVSS_t579 VSS__t579 VSS 0.0531663598974
* device instance VSS_t580 r0 *1 0,0
RVSS_t580 VSS__t580 VSS 0.068953416678
* device instance VSS_t581 r0 *1 0,0
RVSS_t581 VSS__t581 VSS 0.0847404774793
* device instance VSS_t582 r0 *1 0,0
RVSS_t582 VSS__t582 VSS 0.100527540407
* device instance VSS_t583 r0 *1 0,0
RVSS_t583 VSS__t583 VSS 0.116314604596
* device instance VSS_t584 r0 *1 0,0
RVSS_t584 VSS__t584 VSS 0.132101669593
* device instance VSS_t585 r0 *1 0,0
RVSS_t585 VSS__t585 VSS 0.14788873514
* device instance VSS_t586 r0 *1 0,0
RVSS_t586 VSS__t586 VSS 0.163675801077
* device instance VSS_t587 r0 *1 0,0
RVSS_t587 VSS__t587 VSS 0.179462867302
* device instance VSS_t588 r0 *1 0,0
RVSS_t588 VSS__t588 VSS 0.195249933745
* device instance VSS_t589 r0 *1 0,0
RVSS_t589 VSS__t589 VSS 0.211037000357
* device instance VSS_t590 r0 *1 0,0
RVSS_t590 VSS__t590 VSS 0.226824067102
* device instance VSS_t591 r0 *1 0,0
RVSS_t591 VSS__t591 VSS 0.242611133955
* device instance VSS_t592 r0 *1 0,0
RVSS_t592 VSS__t592 VSS 0.258398200896
* device instance VSS_t593 r0 *1 0,0
RVSS_t593 VSS__t593 VSS 0.274185267909
* device instance VSS_t594 r0 *1 0,0
RVSS_t594 VSS__t594 VSS 0.289972334983
* device instance VSS_t595 r0 *1 0,0
RVSS_t595 VSS__t595 VSS 0.305759402109
* device instance VSS_t596 r0 *1 0,0
RVSS_t596 VSS__t596 VSS 0.321546469278
* device instance VSS_t597 r0 *1 0,0
RVSS_t597 VSS__t597 VSS 0.337333536485
* device instance VSS_t598 r0 *1 0,0
RVSS_t598 VSS__t598 VSS 0.353120603725
* device instance VSS_t599 r0 *1 0,0
RVSS_t599 VSS__t599 VSS 0.368907670993
* device instance VSS_t600 r0 *1 0,0
RVSS_t600 VSS__t600 VSS 0.384694738286
* device instance VSS_t601 r0 *1 0,0
RVSS_t601 VSS__t601 VSS 0.400481805601
* device instance VSS_t602 r0 *1 0,0
RVSS_t602 VSS__t602 VSS 0.416268872936
* device instance VSS_t603 r0 *1 0,0
RVSS_t603 VSS__t603 VSS 0.432055940288
* device instance VSS_t604 r0 *1 0,0
RVSS_t604 VSS__t604 VSS 0.447843007655
* device instance VSS_t605 r0 *1 0,0
RVSS_t605 VSS__t605 VSS 0.463630075036
* device instance VSS_t606 r0 *1 0,0
RVSS_t606 VSS__t606 VSS 0.47941714243
* device instance VSS_t607 r0 *1 0,0
RVSS_t607 VSS__t607 VSS 0.495204209835
* device instance VSS_t608 r0 *1 0,0
RVSS_t608 VSS__t608 VSS 0.510991277251
* device instance VSS_t609 r0 *1 0,0
RVSS_t609 VSS__t609 VSS 0.526778344676
* device instance VSS_t610 r0 *1 0,0
RVSS_t610 VSS__t610 VSS 0.542565412109
* device instance VSS_t611 r0 *1 0,0
RVSS_t611 VSS__t611 VSS 0.55835247955
* device instance VSS_t612 r0 *1 0,0
RVSS_t612 VSS__t612 VSS 0.574139546999
* device instance VSS_t613 r0 *1 0,0
RVSS_t613 VSS__t613 VSS 0.589926614454
* device instance VSS_t614 r0 *1 0,0
RVSS_t614 VSS__t614 VSS 0.605713681915
* device instance VSS_t615 r0 *1 0,0
RVSS_t615 VSS__t615 VSS 0.621500749382
* device instance VSS_t616 r0 *1 0,0
RVSS_t616 VSS__t616 VSS 0.637287816854
* device instance VSS_t617 r0 *1 0,0
RVSS_t617 VSS__t617 VSS 0.65307488433
* device instance VSS_t618 r0 *1 0,0
RVSS_t618 VSS__t618 VSS 0.668861951812
* device instance VSS_t619 r0 *1 0,0
RVSS_t619 VSS__t619 VSS 0.684649019297
* device instance VSS_t620 r0 *1 0,0
RVSS_t620 VSS__t620 VSS 0.700436086786
* device instance VSS_t621 r0 *1 0,0
RVSS_t621 VSS__t621 VSS 0.716223154279
* device instance VSS_t622 r0 *1 0,0
RVSS_t622 VSS__t622 VSS 0.732010221776
* device instance VSS_t623 r0 *1 0,0
RVSS_t623 VSS__t623 VSS 0.747797289275
* device instance VSS_t624 r0 *1 0,0
RVSS_t624 VSS__t624 VSS 0.763584356778
* device instance VSS_t625 r0 *1 0,0
RVSS_t625 VSS__t625 VSS 0.779371424283
* device instance VSS_t626 r0 *1 0,0
RVSS_t626 VSS__t626 VSS 0.795158491791
* device instance VSS_t627 r0 *1 0,0
RVSS_t627 VSS__t627 VSS 0.810945559301
* device instance VSS_t628 r0 *1 0,0
RVSS_t628 VSS__t628 VSS 0.826732626814
* device instance VSS_t629 r0 *1 0,0
RVSS_t629 VSS__t629 VSS 0.842519694329
* device instance VSS_t630 r0 *1 0,0
RVSS_t630 VSS__t630 VSS 0.858306761846
* device instance VSS_t631 r0 *1 0,0
RVSS_t631 VSS__t631 VSS 0.874093829365
* device instance VSS_t632 r0 *1 0,0
RVSS_t632 VSS__t632 VSS 0.889880896886
* device instance VSS_t633 r0 *1 0,0
RVSS_t633 VSS__t633 VSS 0.905667964409
* device instance VSS_t634 r0 *1 0,0
RVSS_t634 VSS__t634 VSS 0.921455031934
* device instance VSS_t635 r0 *1 0,0
RVSS_t635 VSS__t635 VSS 0.93724209946
* device instance VSS_t636 r0 *1 0,0
RVSS_t636 VSS__t636 VSS 0.953029166987
* device instance VSS_t637 r0 *1 0,0
RVSS_t637 VSS__t637 VSS 0.968816234516
* device instance VSS_t638 r0 *1 0,0
RVSS_t638 VSS__t638 VSS 0.984603302046
* device instance VSS_t639 r0 *1 0,0
RVSS_t639 VSS__t639 VSS 1.00039036958
* device instance VSS_t640 r0 *1 0,0
RVSS_t640 VSS__t640 VSS 1.00039036958
* device instance VSS_t641 r0 *1 0,0
RVSS_t641 VSS__t641 VSS 0.984603302046
* device instance VSS_t642 r0 *1 0,0
RVSS_t642 VSS__t642 VSS 0.968816234516
* device instance VSS_t643 r0 *1 0,0
RVSS_t643 VSS__t643 VSS 0.953029166987
* device instance VSS_t644 r0 *1 0,0
RVSS_t644 VSS__t644 VSS 0.93724209946
* device instance VSS_t645 r0 *1 0,0
RVSS_t645 VSS__t645 VSS 0.921455031934
* device instance VSS_t646 r0 *1 0,0
RVSS_t646 VSS__t646 VSS 0.905667964409
* device instance VSS_t647 r0 *1 0,0
RVSS_t647 VSS__t647 VSS 0.889880896886
* device instance VSS_t648 r0 *1 0,0
RVSS_t648 VSS__t648 VSS 0.874093829365
* device instance VSS_t649 r0 *1 0,0
RVSS_t649 VSS__t649 VSS 0.858306761846
* device instance VSS_t650 r0 *1 0,0
RVSS_t650 VSS__t650 VSS 0.842519694329
* device instance VSS_t651 r0 *1 0,0
RVSS_t651 VSS__t651 VSS 0.826732626814
* device instance VSS_t652 r0 *1 0,0
RVSS_t652 VSS__t652 VSS 0.810945559301
* device instance VSS_t653 r0 *1 0,0
RVSS_t653 VSS__t653 VSS 0.795158491791
* device instance VSS_t654 r0 *1 0,0
RVSS_t654 VSS__t654 VSS 0.779371424283
* device instance VSS_t655 r0 *1 0,0
RVSS_t655 VSS__t655 VSS 0.763584356778
* device instance VSS_t656 r0 *1 0,0
RVSS_t656 VSS__t656 VSS 0.747797289275
* device instance VSS_t657 r0 *1 0,0
RVSS_t657 VSS__t657 VSS 0.732010221776
* device instance VSS_t658 r0 *1 0,0
RVSS_t658 VSS__t658 VSS 0.716223154279
* device instance VSS_t659 r0 *1 0,0
RVSS_t659 VSS__t659 VSS 0.700436086786
* device instance VSS_t660 r0 *1 0,0
RVSS_t660 VSS__t660 VSS 0.684649019297
* device instance VSS_t661 r0 *1 0,0
RVSS_t661 VSS__t661 VSS 0.668861951812
* device instance VSS_t662 r0 *1 0,0
RVSS_t662 VSS__t662 VSS 0.65307488433
* device instance VSS_t663 r0 *1 0,0
RVSS_t663 VSS__t663 VSS 0.637287816854
* device instance VSS_t664 r0 *1 0,0
RVSS_t664 VSS__t664 VSS 0.621500749382
* device instance VSS_t665 r0 *1 0,0
RVSS_t665 VSS__t665 VSS 0.605713681915
* device instance VSS_t666 r0 *1 0,0
RVSS_t666 VSS__t666 VSS 0.589926614454
* device instance VSS_t667 r0 *1 0,0
RVSS_t667 VSS__t667 VSS 0.574139546999
* device instance VSS_t668 r0 *1 0,0
RVSS_t668 VSS__t668 VSS 0.55835247955
* device instance VSS_t669 r0 *1 0,0
RVSS_t669 VSS__t669 VSS 0.542565412109
* device instance VSS_t670 r0 *1 0,0
RVSS_t670 VSS__t670 VSS 0.526778344676
* device instance VSS_t671 r0 *1 0,0
RVSS_t671 VSS__t671 VSS 0.510991277251
* device instance VSS_t672 r0 *1 0,0
RVSS_t672 VSS__t672 VSS 0.495204209835
* device instance VSS_t673 r0 *1 0,0
RVSS_t673 VSS__t673 VSS 0.47941714243
* device instance VSS_t674 r0 *1 0,0
RVSS_t674 VSS__t674 VSS 0.463630075036
* device instance VSS_t675 r0 *1 0,0
RVSS_t675 VSS__t675 VSS 0.447843007655
* device instance VSS_t676 r0 *1 0,0
RVSS_t676 VSS__t676 VSS 0.432055940288
* device instance VSS_t677 r0 *1 0,0
RVSS_t677 VSS__t677 VSS 0.416268872936
* device instance VSS_t678 r0 *1 0,0
RVSS_t678 VSS__t678 VSS 0.400481805601
* device instance VSS_t679 r0 *1 0,0
RVSS_t679 VSS__t679 VSS 0.384694738286
* device instance VSS_t680 r0 *1 0,0
RVSS_t680 VSS__t680 VSS 0.368907670993
* device instance VSS_t681 r0 *1 0,0
RVSS_t681 VSS__t681 VSS 0.353120603725
* device instance VSS_t682 r0 *1 0,0
RVSS_t682 VSS__t682 VSS 0.337333536485
* device instance VSS_t683 r0 *1 0,0
RVSS_t683 VSS__t683 VSS 0.321546469278
* device instance VSS_t684 r0 *1 0,0
RVSS_t684 VSS__t684 VSS 0.305759402109
* device instance VSS_t685 r0 *1 0,0
RVSS_t685 VSS__t685 VSS 0.289972334983
* device instance VSS_t686 r0 *1 0,0
RVSS_t686 VSS__t686 VSS 0.274185267909
* device instance VSS_t687 r0 *1 0,0
RVSS_t687 VSS__t687 VSS 0.258398200896
* device instance VSS_t688 r0 *1 0,0
RVSS_t688 VSS__t688 VSS 0.242611133955
* device instance VSS_t689 r0 *1 0,0
RVSS_t689 VSS__t689 VSS 0.226824067102
* device instance VSS_t690 r0 *1 0,0
RVSS_t690 VSS__t690 VSS 0.211037000357
* device instance VSS_t691 r0 *1 0,0
RVSS_t691 VSS__t691 VSS 0.195249933745
* device instance VSS_t692 r0 *1 0,0
RVSS_t692 VSS__t692 VSS 0.179462867302
* device instance VSS_t693 r0 *1 0,0
RVSS_t693 VSS__t693 VSS 0.163675801077
* device instance VSS_t694 r0 *1 0,0
RVSS_t694 VSS__t694 VSS 0.14788873514
* device instance VSS_t695 r0 *1 0,0
RVSS_t695 VSS__t695 VSS 0.132101669593
* device instance VSS_t696 r0 *1 0,0
RVSS_t696 VSS__t696 VSS 0.116314604596
* device instance VSS_t697 r0 *1 0,0
RVSS_t697 VSS__t697 VSS 0.100527540407
* device instance VSS_t698 r0 *1 0,0
RVSS_t698 VSS__t698 VSS 0.0847404774793
* device instance VSS_t699 r0 *1 0,0
RVSS_t699 VSS__t699 VSS 0.068953416678
* device instance VSS_t700 r0 *1 0,0
RVSS_t700 VSS__t700 VSS 0.0531663598974
* device instance VSS_t701 r0 *1 0,0
RVSS_t701 VSS__t701 VSS 0.0373793122322
* device instance VSS_t702 r0 *1 0,0
RVSS_t702 VSS__t702 VSS 0.0215922936761
* device instance VSS_t703 r0 *1 0,0
RVSS_t703 VSS__t703 VSS 0.00580554170366
* device instance VSS_t704 r0 *1 0,0
RVSS_t704 VSS__t704 VSS 0.00998220856247
* device instance VSS_t705 r0 *1 0,0
RVSS_t705 VSS__t705 VSS 0.0257691223392
* device instance VSS_t706 r0 *1 0,0
RVSS_t706 VSS__t706 VSS 0.0415561529681
* device instance VSS_t707 r0 *1 0,0
RVSS_t707 VSS__t707 VSS 0.0573432039384
* device instance VSS_t708 r0 *1 0,0
RVSS_t708 VSS__t708 VSS 0.0731302620765
* device instance VSS_t709 r0 *1 0,0
RVSS_t709 VSS__t709 VSS 0.0889173235644
* device instance VSS_t710 r0 *1 0,0
RVSS_t710 VSS__t710 VSS 0.104704386887
* device instance VSS_t711 r0 *1 0,0
RVSS_t711 VSS__t711 VSS 0.120491451323
* device instance VSS_t712 r0 *1 0,0
RVSS_t712 VSS__t712 VSS 0.136278516486
* device instance VSS_t713 r0 *1 0,0
RVSS_t713 VSS__t713 VSS 0.152065582148
* device instance VSS_t714 r0 *1 0,0
RVSS_t714 VSS__t714 VSS 0.16785264817
* device instance VSS_t715 r0 *1 0,0
RVSS_t715 VSS__t715 VSS 0.183639714459
* device instance VSS_t716 r0 *1 0,0
RVSS_t716 VSS__t716 VSS 0.19942678095
* device instance VSS_t717 r0 *1 0,0
RVSS_t717 VSS__t717 VSS 0.2152138476
* device instance VSS_t718 r0 *1 0,0
RVSS_t718 VSS__t718 VSS 0.231000914376
* device instance VSS_t719 r0 *1 0,0
RVSS_t719 VSS__t719 VSS 0.246787981254
* device instance VSS_t720 r0 *1 0,0
RVSS_t720 VSS__t720 VSS 0.262575048216
* device instance VSS_t721 r0 *1 0,0
RVSS_t721 VSS__t721 VSS 0.278362115246
* device instance VSS_t722 r0 *1 0,0
RVSS_t722 VSS__t722 VSS 0.294149182335
* device instance VSS_t723 r0 *1 0,0
RVSS_t723 VSS__t723 VSS 0.309936249473
* device instance VSS_t724 r0 *1 0,0
RVSS_t724 VSS__t724 VSS 0.325723316653
* device instance VSS_t725 r0 *1 0,0
RVSS_t725 VSS__t725 VSS 0.341510383869
* device instance VSS_t726 r0 *1 0,0
RVSS_t726 VSS__t726 VSS 0.357297451116
* device instance VSS_t727 r0 *1 0,0
RVSS_t727 VSS__t727 VSS 0.373084518391
* device instance VSS_t728 r0 *1 0,0
RVSS_t728 VSS__t728 VSS 0.388871585691
* device instance VSS_t729 r0 *1 0,0
RVSS_t729 VSS__t729 VSS 0.404658653011
* device instance VSS_t730 r0 *1 0,0
RVSS_t730 VSS__t730 VSS 0.42044572035
* device instance VSS_t731 r0 *1 0,0
RVSS_t731 VSS__t731 VSS 0.436232787706
* device instance VSS_t732 r0 *1 0,0
RVSS_t732 VSS__t732 VSS 0.452019855078
* device instance VSS_t733 r0 *1 0,0
RVSS_t733 VSS__t733 VSS 0.467806922462
* device instance VSS_t734 r0 *1 0,0
RVSS_t734 VSS__t734 VSS 0.483593989859
* device instance VSS_t735 r0 *1 0,0
RVSS_t735 VSS__t735 VSS 0.499381057267
* device instance VSS_t736 r0 *1 0,0
RVSS_t736 VSS__t736 VSS 0.515168124685
* device instance VSS_t737 r0 *1 0,0
RVSS_t737 VSS__t737 VSS 0.530955192112
* device instance VSS_t738 r0 *1 0,0
RVSS_t738 VSS__t738 VSS 0.546742259548
* device instance VSS_t739 r0 *1 0,0
RVSS_t739 VSS__t739 VSS 0.562529326991
* device instance VSS_t740 r0 *1 0,0
RVSS_t740 VSS__t740 VSS 0.578316394441
* device instance VSS_t741 r0 *1 0,0
RVSS_t741 VSS__t741 VSS 0.594103461898
* device instance VSS_t742 r0 *1 0,0
RVSS_t742 VSS__t742 VSS 0.609890529361
* device instance VSS_t743 r0 *1 0,0
RVSS_t743 VSS__t743 VSS 0.625677596829
* device instance VSS_t744 r0 *1 0,0
RVSS_t744 VSS__t744 VSS 0.641464664302
* device instance VSS_t745 r0 *1 0,0
RVSS_t745 VSS__t745 VSS 0.65725173178
* device instance VSS_t746 r0 *1 0,0
RVSS_t746 VSS__t746 VSS 0.673038799262
* device instance VSS_t747 r0 *1 0,0
RVSS_t747 VSS__t747 VSS 0.688825866749
* device instance VSS_t748 r0 *1 0,0
RVSS_t748 VSS__t748 VSS 0.704612934239
* device instance VSS_t749 r0 *1 0,0
RVSS_t749 VSS__t749 VSS 0.720400001733
* device instance VSS_t750 r0 *1 0,0
RVSS_t750 VSS__t750 VSS 0.73618706923
* device instance VSS_t751 r0 *1 0,0
RVSS_t751 VSS__t751 VSS 0.751974136731
* device instance VSS_t752 r0 *1 0,0
RVSS_t752 VSS__t752 VSS 0.767761204234
* device instance VSS_t753 r0 *1 0,0
RVSS_t753 VSS__t753 VSS 0.78354827174
* device instance VSS_t754 r0 *1 0,0
RVSS_t754 VSS__t754 VSS 0.799335339249
* device instance VSS_t755 r0 *1 0,0
RVSS_t755 VSS__t755 VSS 0.81512240676
* device instance VSS_t756 r0 *1 0,0
RVSS_t756 VSS__t756 VSS 0.830909474273
* device instance VSS_t757 r0 *1 0,0
RVSS_t757 VSS__t757 VSS 0.846696541789
* device instance VSS_t758 r0 *1 0,0
RVSS_t758 VSS__t758 VSS 0.862483609306
* device instance VSS_t759 r0 *1 0,0
RVSS_t759 VSS__t759 VSS 0.878270676826
* device instance VSS_t760 r0 *1 0,0
RVSS_t760 VSS__t760 VSS 0.894057744347
* device instance VSS_t761 r0 *1 0,0
RVSS_t761 VSS__t761 VSS 0.909844811871
* device instance VSS_t762 r0 *1 0,0
RVSS_t762 VSS__t762 VSS 0.925631879395
* device instance VSS_t763 r0 *1 0,0
RVSS_t763 VSS__t763 VSS 0.941418946922
* device instance VSS_t764 r0 *1 0,0
RVSS_t764 VSS__t764 VSS 0.95720601445
* device instance VSS_t765 r0 *1 0,0
RVSS_t765 VSS__t765 VSS 0.972993081979
* device instance VSS_t766 r0 *1 0,0
RVSS_t766 VSS__t766 VSS 0.98878014951
* device instance VSS_t767 r0 *1 0,0
RVSS_t767 VSS__t767 VSS 1.00456721704
* device instance VSS r0 *1 0,0
CVSS VSS vsubs 1.39043126e-13
* device instance WL0_n0 r0 *1 0,0
CWL0_n0 WL0__t0 vsubs 2.81923473003e-16
* device instance WL0_n1 r0 *1 0,0
CWL0_n1 WL0__t1 vsubs 4.3357885848e-16
* device instance WL0_n2 r0 *1 0,0
CWL0_n2 WL0__t233 vsubs 4.3357885848e-16
* device instance WL0_n3 r0 *1 0,0
CWL0_n3 WL0__t51 vsubs 4.3357885848e-16
* device instance WL0_n4 r0 *1 0,0
CWL0_n4 WL0__t235 vsubs 4.3357885848e-16
* device instance WL0_n5 r0 *1 0,0
CWL0_n5 WL0__t57 vsubs 4.3357885848e-16
* device instance WL0_n6 r0 *1 0,0
CWL0_n6 WL0__t154 vsubs 4.3357885848e-16
* device instance WL0_n7 r0 *1 0,0
CWL0_n7 WL0__t42 vsubs 4.3357885848e-16
* device instance WL0_n8 r0 *1 0,0
CWL0_n8 WL0__t148 vsubs 4.3357885848e-16
* device instance WL0_n9 r0 *1 0,0
CWL0_n9 WL0__t5 vsubs 4.3357885848e-16
* device instance WL0_n10 r0 *1 0,0
CWL0_n10 WL0__t137 vsubs 4.3357885848e-16
* device instance WL0_n11 r0 *1 0,0
CWL0_n11 WL0__t8 vsubs 4.3357885848e-16
* device instance WL0_n12 r0 *1 0,0
CWL0_n12 WL0__t178 vsubs 4.3357885848e-16
* device instance WL0_n13 r0 *1 0,0
CWL0_n13 WL0__t56 vsubs 4.3357885848e-16
* device instance WL0_n14 r0 *1 0,0
CWL0_n14 WL0__t158 vsubs 4.3357885848e-16
* device instance WL0_n15 r0 *1 0,0
CWL0_n15 WL0__t46 vsubs 4.3357885848e-16
* device instance WL0_n16 r0 *1 0,0
CWL0_n16 WL0__t215 vsubs 4.3357885848e-16
* device instance WL0_n17 r0 *1 0,0
CWL0_n17 WL0__t22 vsubs 4.3357885848e-16
* device instance WL0_n18 r0 *1 0,0
CWL0_n18 WL0__t219 vsubs 4.3357885848e-16
* device instance WL0_n19 r0 *1 0,0
CWL0_n19 WL0__t25 vsubs 4.3357885848e-16
* device instance WL0_n20 r0 *1 0,0
CWL0_n20 WL0__t213 vsubs 4.3357885848e-16
* device instance WL0_n21 r0 *1 0,0
CWL0_n21 WL0__t28 vsubs 4.3357885848e-16
* device instance WL0_n22 r0 *1 0,0
CWL0_n22 WL0__t202 vsubs 4.3357885848e-16
* device instance WL0_n23 r0 *1 0,0
CWL0_n23 WL0__t38 vsubs 4.3357885848e-16
* device instance WL0_n24 r0 *1 0,0
CWL0_n24 WL0__t250 vsubs 4.3357885848e-16
* device instance WL0_n25 r0 *1 0,0
CWL0_n25 WL0__t31 vsubs 4.3357885848e-16
* device instance WL0_n26 r0 *1 0,0
CWL0_n26 WL0__t253 vsubs 4.3357885848e-16
* device instance WL0_n27 r0 *1 0,0
CWL0_n27 WL0__t24 vsubs 4.3357885848e-16
* device instance WL0_n28 r0 *1 0,0
CWL0_n28 WL0__t224 vsubs 4.3357885848e-16
* device instance WL0_n29 r0 *1 0,0
CWL0_n29 WL0__t23 vsubs 4.3357885848e-16
* device instance WL0_n30 r0 *1 0,0
CWL0_n30 WL0__t227 vsubs 4.3357885848e-16
* device instance WL0_n31 r0 *1 0,0
CWL0_n31 WL0__t21 vsubs 4.3357885848e-16
* device instance WL0_n32 r0 *1 0,0
CWL0_n32 WL0__t140 vsubs 4.3357885848e-16
* device instance WL0_n33 r0 *1 0,0
CWL0_n33 WL0__t112 vsubs 4.3357885848e-16
* device instance WL0_n34 r0 *1 0,0
CWL0_n34 WL0__t133 vsubs 4.3357885848e-16
* device instance WL0_n35 r0 *1 0,0
CWL0_n35 WL0__t111 vsubs 4.3357885848e-16
* device instance WL0_n36 r0 *1 0,0
CWL0_n36 WL0__t162 vsubs 4.3357885848e-16
* device instance WL0_n37 r0 *1 0,0
CWL0_n37 WL0__t114 vsubs 4.3357885848e-16
* device instance WL0_n38 r0 *1 0,0
CWL0_n38 WL0__t182 vsubs 4.3357885848e-16
* device instance WL0_n39 r0 *1 0,0
CWL0_n39 WL0__t117 vsubs 4.3357885848e-16
* device instance WL0_n40 r0 *1 0,0
CWL0_n40 WL0__t156 vsubs 4.3357885848e-16
* device instance WL0_n41 r0 *1 0,0
CWL0_n41 WL0__t120 vsubs 4.3357885848e-16
* device instance WL0_n42 r0 *1 0,0
CWL0_n42 WL0__t165 vsubs 4.3357885848e-16
* device instance WL0_n43 r0 *1 0,0
CWL0_n43 WL0__t127 vsubs 4.3357885848e-16
* device instance WL0_n44 r0 *1 0,0
CWL0_n44 WL0__t170 vsubs 4.3357885848e-16
* device instance WL0_n45 r0 *1 0,0
CWL0_n45 WL0__t29 vsubs 4.3357885848e-16
* device instance WL0_n46 r0 *1 0,0
CWL0_n46 WL0__t161 vsubs 4.3357885848e-16
* device instance WL0_n47 r0 *1 0,0
CWL0_n47 WL0__t15 vsubs 4.3357885848e-16
* device instance WL0_n48 r0 *1 0,0
CWL0_n48 WL0__t186 vsubs 4.3357885848e-16
* device instance WL0_n49 r0 *1 0,0
CWL0_n49 WL0__t9 vsubs 4.3357885848e-16
* device instance WL0_n50 r0 *1 0,0
CWL0_n50 WL0__t237 vsubs 4.3357885848e-16
* device instance WL0_n51 r0 *1 0,0
CWL0_n51 WL0__t6 vsubs 4.3357885848e-16
* device instance WL0_n52 r0 *1 0,0
CWL0_n52 WL0__t199 vsubs 4.3357885848e-16
* device instance WL0_n53 r0 *1 0,0
CWL0_n53 WL0__t45 vsubs 4.3357885848e-16
* device instance WL0_n54 r0 *1 0,0
CWL0_n54 WL0__t192 vsubs 4.3357885848e-16
* device instance WL0_n55 r0 *1 0,0
CWL0_n55 WL0__t47 vsubs 4.3357885848e-16
* device instance WL0_n56 r0 *1 0,0
CWL0_n56 WL0__t216 vsubs 4.3357885848e-16
* device instance WL0_n57 r0 *1 0,0
CWL0_n57 WL0__t50 vsubs 4.3357885848e-16
* device instance WL0_n58 r0 *1 0,0
CWL0_n58 WL0__t207 vsubs 4.3357885848e-16
* device instance WL0_n59 r0 *1 0,0
CWL0_n59 WL0__t52 vsubs 4.3357885848e-16
* device instance WL0_n60 r0 *1 0,0
CWL0_n60 WL0__t208 vsubs 4.3357885848e-16
* device instance WL0_n61 r0 *1 0,0
CWL0_n61 WL0__t54 vsubs 4.3357885848e-16
* device instance WL0_n62 r0 *1 0,0
CWL0_n62 WL0__t212 vsubs 4.3357885848e-16
* device instance WL0_n63 r0 *1 0,0
CWL0_n63 WL0__t48 vsubs 4.3357885848e-16
* device instance WL0_n64 r0 *1 0,0
CWL0_n64 WL0__t139 vsubs 4.3357885848e-16
* device instance WL0_n65 r0 *1 0,0
CWL0_n65 WL0__t100 vsubs 4.3357885848e-16
* device instance WL0_n66 r0 *1 0,0
CWL0_n66 WL0__t141 vsubs 4.3357885848e-16
* device instance WL0_n67 r0 *1 0,0
CWL0_n67 WL0__t101 vsubs 4.3357885848e-16
* device instance WL0_n68 r0 *1 0,0
CWL0_n68 WL0__t144 vsubs 4.3357885848e-16
* device instance WL0_n69 r0 *1 0,0
CWL0_n69 WL0__t102 vsubs 4.3357885848e-16
* device instance WL0_n70 r0 *1 0,0
CWL0_n70 WL0__t149 vsubs 4.3357885848e-16
* device instance WL0_n71 r0 *1 0,0
CWL0_n71 WL0__t103 vsubs 4.3357885848e-16
* device instance WL0_n72 r0 *1 0,0
CWL0_n72 WL0__t151 vsubs 4.3357885848e-16
* device instance WL0_n73 r0 *1 0,0
CWL0_n73 WL0__t104 vsubs 4.3357885848e-16
* device instance WL0_n74 r0 *1 0,0
CWL0_n74 WL0__t150 vsubs 4.3357885848e-16
* device instance WL0_n75 r0 *1 0,0
CWL0_n75 WL0__t105 vsubs 4.3357885848e-16
* device instance WL0_n76 r0 *1 0,0
CWL0_n76 WL0__t135 vsubs 4.3357885848e-16
* device instance WL0_n77 r0 *1 0,0
CWL0_n77 WL0__t106 vsubs 4.3357885848e-16
* device instance WL0_n78 r0 *1 0,0
CWL0_n78 WL0__t174 vsubs 4.3357885848e-16
* device instance WL0_n79 r0 *1 0,0
CWL0_n79 WL0__t107 vsubs 4.3357885848e-16
* device instance WL0_n80 r0 *1 0,0
CWL0_n80 WL0__t236 vsubs 4.3357885848e-16
* device instance WL0_n81 r0 *1 0,0
CWL0_n81 WL0__t96 vsubs 4.3357885848e-16
* device instance WL0_n82 r0 *1 0,0
CWL0_n82 WL0__t226 vsubs 4.3357885848e-16
* device instance WL0_n83 r0 *1 0,0
CWL0_n83 WL0__t62 vsubs 4.3357885848e-16
* device instance WL0_n84 r0 *1 0,0
CWL0_n84 WL0__t247 vsubs 4.3357885848e-16
* device instance WL0_n85 r0 *1 0,0
CWL0_n85 WL0__t67 vsubs 4.3357885848e-16
* device instance WL0_n86 r0 *1 0,0
CWL0_n86 WL0__t200 vsubs 4.3357885848e-16
* device instance WL0_n87 r0 *1 0,0
CWL0_n87 WL0__t72 vsubs 4.3357885848e-16
* device instance WL0_n88 r0 *1 0,0
CWL0_n88 WL0__t189 vsubs 4.3357885848e-16
* device instance WL0_n89 r0 *1 0,0
CWL0_n89 WL0__t77 vsubs 4.3357885848e-16
* device instance WL0_n90 r0 *1 0,0
CWL0_n90 WL0__t211 vsubs 4.3357885848e-16
* device instance WL0_n91 r0 *1 0,0
CWL0_n91 WL0__t82 vsubs 4.3357885848e-16
* device instance WL0_n92 r0 *1 0,0
CWL0_n92 WL0__t220 vsubs 4.3357885848e-16
* device instance WL0_n93 r0 *1 0,0
CWL0_n93 WL0__t116 vsubs 4.3357885848e-16
* device instance WL0_n94 r0 *1 0,0
CWL0_n94 WL0__t246 vsubs 4.3357885848e-16
* device instance WL0_n95 r0 *1 0,0
CWL0_n95 WL0__t121 vsubs 4.3357885848e-16
* device instance WL0_n96 r0 *1 0,0
CWL0_n96 WL0__t185 vsubs 4.3357885848e-16
* device instance WL0_n97 r0 *1 0,0
CWL0_n97 WL0__t91 vsubs 4.3357885848e-16
* device instance WL0_n98 r0 *1 0,0
CWL0_n98 WL0__t187 vsubs 4.3357885848e-16
* device instance WL0_n99 r0 *1 0,0
CWL0_n99 WL0__t90 vsubs 4.3357885848e-16
* device instance WL0_n100 r0 *1 0,0
CWL0_n100 WL0__t155 vsubs 4.3357885848e-16
* device instance WL0_n101 r0 *1 0,0
CWL0_n101 WL0__t89 vsubs 4.3357885848e-16
* device instance WL0_n102 r0 *1 0,0
CWL0_n102 WL0__t159 vsubs 4.3357885848e-16
* device instance WL0_n103 r0 *1 0,0
CWL0_n103 WL0__t87 vsubs 4.3357885848e-16
* device instance WL0_n104 r0 *1 0,0
CWL0_n104 WL0__t163 vsubs 4.3357885848e-16
* device instance WL0_n105 r0 *1 0,0
CWL0_n105 WL0__t86 vsubs 4.3357885848e-16
* device instance WL0_n106 r0 *1 0,0
CWL0_n106 WL0__t166 vsubs 4.3357885848e-16
* device instance WL0_n107 r0 *1 0,0
CWL0_n107 WL0__t85 vsubs 4.3357885848e-16
* device instance WL0_n108 r0 *1 0,0
CWL0_n108 WL0__t169 vsubs 4.3357885848e-16
* device instance WL0_n109 r0 *1 0,0
CWL0_n109 WL0__t84 vsubs 4.3357885848e-16
* device instance WL0_n110 r0 *1 0,0
CWL0_n110 WL0__t171 vsubs 4.3357885848e-16
* device instance WL0_n111 r0 *1 0,0
CWL0_n111 WL0__t88 vsubs 4.3357885848e-16
* device instance WL0_n112 r0 *1 0,0
CWL0_n112 WL0__t183 vsubs 4.3357885848e-16
* device instance WL0_n113 r0 *1 0,0
CWL0_n113 WL0__t92 vsubs 4.3357885848e-16
* device instance WL0_n114 r0 *1 0,0
CWL0_n114 WL0__t181 vsubs 4.3357885848e-16
* device instance WL0_n115 r0 *1 0,0
CWL0_n115 WL0__t93 vsubs 4.3357885848e-16
* device instance WL0_n116 r0 *1 0,0
CWL0_n116 WL0__t188 vsubs 4.3357885848e-16
* device instance WL0_n117 r0 *1 0,0
CWL0_n117 WL0__t94 vsubs 4.3357885848e-16
* device instance WL0_n118 r0 *1 0,0
CWL0_n118 WL0__t175 vsubs 4.3357885848e-16
* device instance WL0_n119 r0 *1 0,0
CWL0_n119 WL0__t95 vsubs 4.3357885848e-16
* device instance WL0_n120 r0 *1 0,0
CWL0_n120 WL0__t172 vsubs 4.3357885848e-16
* device instance WL0_n121 r0 *1 0,0
CWL0_n121 WL0__t109 vsubs 4.3357885848e-16
* device instance WL0_n122 r0 *1 0,0
CWL0_n122 WL0__t145 vsubs 4.3357885848e-16
* device instance WL0_n123 r0 *1 0,0
CWL0_n123 WL0__t97 vsubs 4.3357885848e-16
* device instance WL0_n124 r0 *1 0,0
CWL0_n124 WL0__t129 vsubs 4.3357885848e-16
* device instance WL0_n125 r0 *1 0,0
CWL0_n125 WL0__t98 vsubs 4.3357885848e-16
* device instance WL0_n126 r0 *1 0,0
CWL0_n126 WL0__t132 vsubs 4.3357885848e-16
* device instance WL0_n127 r0 *1 0,0
CWL0_n127 WL0__t99 vsubs 4.3357885848e-16
* device instance WL0_n128 r0 *1 0,0
CWL0_n128 WL0 vsubs 4.3357885848e-16
* device instance WL0_n129 r0 *1 0,0
CWL0_n129 WL0__t75 vsubs 4.3357885848e-16
* device instance WL0_n130 r0 *1 0,0
CWL0_n130 WL0__t193 vsubs 4.3357885848e-16
* device instance WL0_n131 r0 *1 0,0
CWL0_n131 WL0__t74 vsubs 4.3357885848e-16
* device instance WL0_n132 r0 *1 0,0
CWL0_n132 WL0__t205 vsubs 4.3357885848e-16
* device instance WL0_n133 r0 *1 0,0
CWL0_n133 WL0__t73 vsubs 4.3357885848e-16
* device instance WL0_n134 r0 *1 0,0
CWL0_n134 WL0__t198 vsubs 4.3357885848e-16
* device instance WL0_n135 r0 *1 0,0
CWL0_n135 WL0__t71 vsubs 4.3357885848e-16
* device instance WL0_n136 r0 *1 0,0
CWL0_n136 WL0__t203 vsubs 4.3357885848e-16
* device instance WL0_n137 r0 *1 0,0
CWL0_n137 WL0__t83 vsubs 4.3357885848e-16
* device instance WL0_n138 r0 *1 0,0
CWL0_n138 WL0__t239 vsubs 4.3357885848e-16
* device instance WL0_n139 r0 *1 0,0
CWL0_n139 WL0__t69 vsubs 4.3357885848e-16
* device instance WL0_n140 r0 *1 0,0
CWL0_n140 WL0__t241 vsubs 4.3357885848e-16
* device instance WL0_n141 r0 *1 0,0
CWL0_n141 WL0__t68 vsubs 4.3357885848e-16
* device instance WL0_n142 r0 *1 0,0
CWL0_n142 WL0__t244 vsubs 4.3357885848e-16
* device instance WL0_n143 r0 *1 0,0
CWL0_n143 WL0__t122 vsubs 4.3357885848e-16
* device instance WL0_n144 r0 *1 0,0
CWL0_n144 WL0__t248 vsubs 4.3357885848e-16
* device instance WL0_n145 r0 *1 0,0
CWL0_n145 WL0__t65 vsubs 4.3357885848e-16
* device instance WL0_n146 r0 *1 0,0
CWL0_n146 WL0__t251 vsubs 4.3357885848e-16
* device instance WL0_n147 r0 *1 0,0
CWL0_n147 WL0__t64 vsubs 4.3357885848e-16
* device instance WL0_n148 r0 *1 0,0
CWL0_n148 WL0__t254 vsubs 4.3357885848e-16
* device instance WL0_n149 r0 *1 0,0
CWL0_n149 WL0__t63 vsubs 4.3357885848e-16
* device instance WL0_n150 r0 *1 0,0
CWL0_n150 WL0__t225 vsubs 4.3357885848e-16
* device instance WL0_n151 r0 *1 0,0
CWL0_n151 WL0__t61 vsubs 4.3357885848e-16
* device instance WL0_n152 r0 *1 0,0
CWL0_n152 WL0__t228 vsubs 4.3357885848e-16
* device instance WL0_n153 r0 *1 0,0
CWL0_n153 WL0__t60 vsubs 4.3357885848e-16
* device instance WL0_n154 r0 *1 0,0
CWL0_n154 WL0__t238 vsubs 4.3357885848e-16
* device instance WL0_n155 r0 *1 0,0
CWL0_n155 WL0__t59 vsubs 4.3357885848e-16
* device instance WL0_n156 r0 *1 0,0
CWL0_n156 WL0__t231 vsubs 4.3357885848e-16
* device instance WL0_n157 r0 *1 0,0
CWL0_n157 WL0__t58 vsubs 4.3357885848e-16
* device instance WL0_n158 r0 *1 0,0
CWL0_n158 WL0__t196 vsubs 4.3357885848e-16
* device instance WL0_n159 r0 *1 0,0
CWL0_n159 WL0__t108 vsubs 4.3357885848e-16
* device instance WL0_n160 r0 *1 0,0
CWL0_n160 WL0__t143 vsubs 4.3357885848e-16
* device instance WL0_n161 r0 *1 0,0
CWL0_n161 WL0__t119 vsubs 4.3357885848e-16
* device instance WL0_n162 r0 *1 0,0
CWL0_n162 WL0__t153 vsubs 4.3357885848e-16
* device instance WL0_n163 r0 *1 0,0
CWL0_n163 WL0__t123 vsubs 4.3357885848e-16
* device instance WL0_n164 r0 *1 0,0
CWL0_n164 WL0__t234 vsubs 4.3357885848e-16
* device instance WL0_n165 r0 *1 0,0
CWL0_n165 WL0__t125 vsubs 4.3357885848e-16
* device instance WL0_n166 r0 *1 0,0
CWL0_n166 WL0__t229 vsubs 4.3357885848e-16
* device instance WL0_n167 r0 *1 0,0
CWL0_n167 WL0__t128 vsubs 4.3357885848e-16
* device instance WL0_n168 r0 *1 0,0
CWL0_n168 WL0__t252 vsubs 4.3357885848e-16
* device instance WL0_n169 r0 *1 0,0
CWL0_n169 WL0__t113 vsubs 4.3357885848e-16
* device instance WL0_n170 r0 *1 0,0
CWL0_n170 WL0__t243 vsubs 4.3357885848e-16
* device instance WL0_n171 r0 *1 0,0
CWL0_n171 WL0__t110 vsubs 4.3357885848e-16
* device instance WL0_n172 r0 *1 0,0
CWL0_n172 WL0__t240 vsubs 4.3357885848e-16
* device instance WL0_n173 r0 *1 0,0
CWL0_n173 WL0__t115 vsubs 4.3357885848e-16
* device instance WL0_n174 r0 *1 0,0
CWL0_n174 WL0__t194 vsubs 4.3357885848e-16
* device instance WL0_n175 r0 *1 0,0
CWL0_n175 WL0__t118 vsubs 4.3357885848e-16
* device instance WL0_n176 r0 *1 0,0
CWL0_n176 WL0__t218 vsubs 4.3357885848e-16
* device instance WL0_n177 r0 *1 0,0
CWL0_n177 WL0__t126 vsubs 4.3357885848e-16
* device instance WL0_n178 r0 *1 0,0
CWL0_n178 WL0__t210 vsubs 4.3357885848e-16
* device instance WL0_n179 r0 *1 0,0
CWL0_n179 WL0__t124 vsubs 4.3357885848e-16
* device instance WL0_n180 r0 *1 0,0
CWL0_n180 WL0__t206 vsubs 4.3357885848e-16
* device instance WL0_n181 r0 *1 0,0
CWL0_n181 WL0__t70 vsubs 4.3357885848e-16
* device instance WL0_n182 r0 *1 0,0
CWL0_n182 WL0__t209 vsubs 4.3357885848e-16
* device instance WL0_n183 r0 *1 0,0
CWL0_n183 WL0__t81 vsubs 4.3357885848e-16
* device instance WL0_n184 r0 *1 0,0
CWL0_n184 WL0__t222 vsubs 4.3357885848e-16
* device instance WL0_n185 r0 *1 0,0
CWL0_n185 WL0__t80 vsubs 4.3357885848e-16
* device instance WL0_n186 r0 *1 0,0
CWL0_n186 WL0__t214 vsubs 4.3357885848e-16
* device instance WL0_n187 r0 *1 0,0
CWL0_n187 WL0__t79 vsubs 4.3357885848e-16
* device instance WL0_n188 r0 *1 0,0
CWL0_n188 WL0__t217 vsubs 4.3357885848e-16
* device instance WL0_n189 r0 *1 0,0
CWL0_n189 WL0__t78 vsubs 4.3357885848e-16
* device instance WL0_n190 r0 *1 0,0
CWL0_n190 WL0__t221 vsubs 4.3357885848e-16
* device instance WL0_n191 r0 *1 0,0
CWL0_n191 WL0__t76 vsubs 4.3357885848e-16
* device instance WL0_n192 r0 *1 0,0
CWL0_n192 WL0__t204 vsubs 4.3357885848e-16
* device instance WL0_n193 r0 *1 0,0
CWL0_n193 WL0__t44 vsubs 4.3357885848e-16
* device instance WL0_n194 r0 *1 0,0
CWL0_n194 WL0__t255 vsubs 4.3357885848e-16
* device instance WL0_n195 r0 *1 0,0
CWL0_n195 WL0__t41 vsubs 4.3357885848e-16
* device instance WL0_n196 r0 *1 0,0
CWL0_n196 WL0__t223 vsubs 4.3357885848e-16
* device instance WL0_n197 r0 *1 0,0
CWL0_n197 WL0__t40 vsubs 4.3357885848e-16
* device instance WL0_n198 r0 *1 0,0
CWL0_n198 WL0__t232 vsubs 4.3357885848e-16
* device instance WL0_n199 r0 *1 0,0
CWL0_n199 WL0__t7 vsubs 4.3357885848e-16
* device instance WL0_n200 r0 *1 0,0
CWL0_n200 WL0__t136 vsubs 4.3357885848e-16
* device instance WL0_n201 r0 *1 0,0
CWL0_n201 WL0__t10 vsubs 4.3357885848e-16
* device instance WL0_n202 r0 *1 0,0
CWL0_n202 WL0__t146 vsubs 4.3357885848e-16
* device instance WL0_n203 r0 *1 0,0
CWL0_n203 WL0__t19 vsubs 4.3357885848e-16
* device instance WL0_n204 r0 *1 0,0
CWL0_n204 WL0__t130 vsubs 4.3357885848e-16
* device instance WL0_n205 r0 *1 0,0
CWL0_n205 WL0__t11 vsubs 4.3357885848e-16
* device instance WL0_n206 r0 *1 0,0
CWL0_n206 WL0__t176 vsubs 4.3357885848e-16
* device instance WL0_n207 r0 *1 0,0
CWL0_n207 WL0__t4 vsubs 4.3357885848e-16
* device instance WL0_n208 r0 *1 0,0
CWL0_n208 WL0__t249 vsubs 4.3357885848e-16
* device instance WL0_n209 r0 *1 0,0
CWL0_n209 WL0__t32 vsubs 4.3357885848e-16
* device instance WL0_n210 r0 *1 0,0
CWL0_n210 WL0__t245 vsubs 4.3357885848e-16
* device instance WL0_n211 r0 *1 0,0
CWL0_n211 WL0__t34 vsubs 4.3357885848e-16
* device instance WL0_n212 r0 *1 0,0
CWL0_n212 WL0__t242 vsubs 4.3357885848e-16
* device instance WL0_n213 r0 *1 0,0
CWL0_n213 WL0__t37 vsubs 4.3357885848e-16
* device instance WL0_n214 r0 *1 0,0
CWL0_n214 WL0__t230 vsubs 4.3357885848e-16
* device instance WL0_n215 r0 *1 0,0
CWL0_n215 WL0__t36 vsubs 4.3357885848e-16
* device instance WL0_n216 r0 *1 0,0
CWL0_n216 WL0__t201 vsubs 4.3357885848e-16
* device instance WL0_n217 r0 *1 0,0
CWL0_n217 WL0__t35 vsubs 4.3357885848e-16
* device instance WL0_n218 r0 *1 0,0
CWL0_n218 WL0__t197 vsubs 4.3357885848e-16
* device instance WL0_n219 r0 *1 0,0
CWL0_n219 WL0__t33 vsubs 4.3357885848e-16
* device instance WL0_n220 r0 *1 0,0
CWL0_n220 WL0__t195 vsubs 4.3357885848e-16
* device instance WL0_n221 r0 *1 0,0
CWL0_n221 WL0__t30 vsubs 4.3357885848e-16
* device instance WL0_n222 r0 *1 0,0
CWL0_n222 WL0__t191 vsubs 4.3357885848e-16
* device instance WL0_n223 r0 *1 0,0
CWL0_n223 WL0__t27 vsubs 4.3357885848e-16
* device instance WL0_n224 r0 *1 0,0
CWL0_n224 WL0__t168 vsubs 4.3357885848e-16
* device instance WL0_n225 r0 *1 0,0
CWL0_n225 WL0__t66 vsubs 4.3357885848e-16
* device instance WL0_n226 r0 *1 0,0
CWL0_n226 WL0__t167 vsubs 4.3357885848e-16
* device instance WL0_n227 r0 *1 0,0
CWL0_n227 WL0__t18 vsubs 4.3357885848e-16
* device instance WL0_n228 r0 *1 0,0
CWL0_n228 WL0__t164 vsubs 4.3357885848e-16
* device instance WL0_n229 r0 *1 0,0
CWL0_n229 WL0__t12 vsubs 4.3357885848e-16
* device instance WL0_n230 r0 *1 0,0
CWL0_n230 WL0__t160 vsubs 4.3357885848e-16
* device instance WL0_n231 r0 *1 0,0
CWL0_n231 WL0__t49 vsubs 4.3357885848e-16
* device instance WL0_n232 r0 *1 0,0
CWL0_n232 WL0__t157 vsubs 4.3357885848e-16
* device instance WL0_n233 r0 *1 0,0
CWL0_n233 WL0__t53 vsubs 4.3357885848e-16
* device instance WL0_n234 r0 *1 0,0
CWL0_n234 WL0__t179 vsubs 4.3357885848e-16
* device instance WL0_n235 r0 *1 0,0
CWL0_n235 WL0__t26 vsubs 4.3357885848e-16
* device instance WL0_n236 r0 *1 0,0
CWL0_n236 WL0__t184 vsubs 4.3357885848e-16
* device instance WL0_n237 r0 *1 0,0
CWL0_n237 WL0__t39 vsubs 4.3357885848e-16
* device instance WL0_n238 r0 *1 0,0
CWL0_n238 WL0__t180 vsubs 4.3357885848e-16
* device instance WL0_n239 r0 *1 0,0
CWL0_n239 WL0__t55 vsubs 4.3357885848e-16
* device instance WL0_n240 r0 *1 0,0
CWL0_n240 WL0__t177 vsubs 4.3357885848e-16
* device instance WL0_n241 r0 *1 0,0
CWL0_n241 WL0__t43 vsubs 4.3357885848e-16
* device instance WL0_n242 r0 *1 0,0
CWL0_n242 WL0__t173 vsubs 4.3357885848e-16
* device instance WL0_n243 r0 *1 0,0
CWL0_n243 WL0__t14 vsubs 4.3357885848e-16
* device instance WL0_n244 r0 *1 0,0
CWL0_n244 WL0__t134 vsubs 4.3357885848e-16
* device instance WL0_n245 r0 *1 0,0
CWL0_n245 WL0__t2 vsubs 4.3357885848e-16
* device instance WL0_n246 r0 *1 0,0
CWL0_n246 WL0__t131 vsubs 4.3357885848e-16
* device instance WL0_n247 r0 *1 0,0
CWL0_n247 WL0__t16 vsubs 4.3357885848e-16
* device instance WL0_n248 r0 *1 0,0
CWL0_n248 WL0__t138 vsubs 4.3357885848e-16
* device instance WL0_n249 r0 *1 0,0
CWL0_n249 WL0__t17 vsubs 4.3357885848e-16
* device instance WL0_n250 r0 *1 0,0
CWL0_n250 WL0__t142 vsubs 4.3357885848e-16
* device instance WL0_n251 r0 *1 0,0
CWL0_n251 WL0__t20 vsubs 4.3357885848e-16
* device instance WL0_n252 r0 *1 0,0
CWL0_n252 WL0__t147 vsubs 4.3357885848e-16
* device instance WL0_n253 r0 *1 0,0
CWL0_n253 WL0__t13 vsubs 4.3357885848e-16
* device instance WL0_n254 r0 *1 0,0
CWL0_n254 WL0__t152 vsubs 4.3357885848e-16
* device instance WL0_n255 r0 *1 0,0
CWL0_n255 WL0__t3 vsubs 2.81923473003e-16
* device instance WL0_seg0 r0 *1 0,0
RWL0_seg0 WL0__t0 WL0__t1 111.888796652
* device instance WL0_seg1 r0 *1 0,0
RWL0_seg1 WL0__t1 WL0__t233 60.1884561301
* device instance WL0_seg2 r0 *1 0,0
RWL0_seg2 WL0__t233 WL0__t51 111.888796652
* device instance WL0_seg3 r0 *1 0,0
RWL0_seg3 WL0__t51 WL0__t235 60.1884561301
* device instance WL0_seg4 r0 *1 0,0
RWL0_seg4 WL0__t235 WL0__t57 111.888796652
* device instance WL0_seg5 r0 *1 0,0
RWL0_seg5 WL0__t57 WL0__t154 60.1884561301
* device instance WL0_seg6 r0 *1 0,0
RWL0_seg6 WL0__t154 WL0__t42 111.888796652
* device instance WL0_seg7 r0 *1 0,0
RWL0_seg7 WL0__t42 WL0__t148 60.1884561301
* device instance WL0_seg8 r0 *1 0,0
RWL0_seg8 WL0__t148 WL0__t5 111.888796652
* device instance WL0_seg9 r0 *1 0,0
RWL0_seg9 WL0__t5 WL0__t137 60.1884561301
* device instance WL0_seg10 r0 *1 0,0
RWL0_seg10 WL0__t137 WL0__t8 111.888796652
* device instance WL0_seg11 r0 *1 0,0
RWL0_seg11 WL0__t8 WL0__t178 60.1884561301
* device instance WL0_seg12 r0 *1 0,0
RWL0_seg12 WL0__t178 WL0__t56 111.888796652
* device instance WL0_seg13 r0 *1 0,0
RWL0_seg13 WL0__t56 WL0__t158 60.1884561301
* device instance WL0_seg14 r0 *1 0,0
RWL0_seg14 WL0__t158 WL0__t46 111.888796652
* device instance WL0_seg15 r0 *1 0,0
RWL0_seg15 WL0__t46 WL0__t215 60.1884561301
* device instance WL0_seg16 r0 *1 0,0
RWL0_seg16 WL0__t215 WL0__t22 111.888796652
* device instance WL0_seg17 r0 *1 0,0
RWL0_seg17 WL0__t22 WL0__t219 60.1884561301
* device instance WL0_seg18 r0 *1 0,0
RWL0_seg18 WL0__t219 WL0__t25 111.888796652
* device instance WL0_seg19 r0 *1 0,0
RWL0_seg19 WL0__t25 WL0__t213 60.1884561301
* device instance WL0_seg20 r0 *1 0,0
RWL0_seg20 WL0__t213 WL0__t28 111.888796652
* device instance WL0_seg21 r0 *1 0,0
RWL0_seg21 WL0__t28 WL0__t202 60.1884561301
* device instance WL0_seg22 r0 *1 0,0
RWL0_seg22 WL0__t202 WL0__t38 111.888796652
* device instance WL0_seg23 r0 *1 0,0
RWL0_seg23 WL0__t38 WL0__t250 60.1884561301
* device instance WL0_seg24 r0 *1 0,0
RWL0_seg24 WL0__t250 WL0__t31 111.888796652
* device instance WL0_seg25 r0 *1 0,0
RWL0_seg25 WL0__t31 WL0__t253 60.1884561301
* device instance WL0_seg26 r0 *1 0,0
RWL0_seg26 WL0__t253 WL0__t24 111.888796652
* device instance WL0_seg27 r0 *1 0,0
RWL0_seg27 WL0__t24 WL0__t224 60.1884561301
* device instance WL0_seg28 r0 *1 0,0
RWL0_seg28 WL0__t224 WL0__t23 111.888796652
* device instance WL0_seg29 r0 *1 0,0
RWL0_seg29 WL0__t23 WL0__t227 60.1884561301
* device instance WL0_seg30 r0 *1 0,0
RWL0_seg30 WL0__t227 WL0__t21 111.888796652
* device instance WL0_seg31 r0 *1 0,0
RWL0_seg31 WL0__t21 WL0__t140 60.1884561301
* device instance WL0_seg32 r0 *1 0,0
RWL0_seg32 WL0__t140 WL0__t112 111.888796652
* device instance WL0_seg33 r0 *1 0,0
RWL0_seg33 WL0__t112 WL0__t133 60.1884561301
* device instance WL0_seg34 r0 *1 0,0
RWL0_seg34 WL0__t133 WL0__t111 111.888796652
* device instance WL0_seg35 r0 *1 0,0
RWL0_seg35 WL0__t111 WL0__t162 60.1884561301
* device instance WL0_seg36 r0 *1 0,0
RWL0_seg36 WL0__t162 WL0__t114 111.888796652
* device instance WL0_seg37 r0 *1 0,0
RWL0_seg37 WL0__t114 WL0__t182 60.1884561301
* device instance WL0_seg38 r0 *1 0,0
RWL0_seg38 WL0__t182 WL0__t117 111.888796652
* device instance WL0_seg39 r0 *1 0,0
RWL0_seg39 WL0__t117 WL0__t156 60.1884561301
* device instance WL0_seg40 r0 *1 0,0
RWL0_seg40 WL0__t156 WL0__t120 111.888796652
* device instance WL0_seg41 r0 *1 0,0
RWL0_seg41 WL0__t120 WL0__t165 60.1884561301
* device instance WL0_seg42 r0 *1 0,0
RWL0_seg42 WL0__t165 WL0__t127 111.888796652
* device instance WL0_seg43 r0 *1 0,0
RWL0_seg43 WL0__t127 WL0__t170 60.1884561301
* device instance WL0_seg44 r0 *1 0,0
RWL0_seg44 WL0__t170 WL0__t29 111.888796652
* device instance WL0_seg45 r0 *1 0,0
RWL0_seg45 WL0__t29 WL0__t161 60.1884561301
* device instance WL0_seg46 r0 *1 0,0
RWL0_seg46 WL0__t161 WL0__t15 111.888796652
* device instance WL0_seg47 r0 *1 0,0
RWL0_seg47 WL0__t15 WL0__t186 60.1884561301
* device instance WL0_seg48 r0 *1 0,0
RWL0_seg48 WL0__t186 WL0__t9 111.888796652
* device instance WL0_seg49 r0 *1 0,0
RWL0_seg49 WL0__t9 WL0__t237 60.1884561301
* device instance WL0_seg50 r0 *1 0,0
RWL0_seg50 WL0__t237 WL0__t6 111.888796652
* device instance WL0_seg51 r0 *1 0,0
RWL0_seg51 WL0__t6 WL0__t199 60.1884561301
* device instance WL0_seg52 r0 *1 0,0
RWL0_seg52 WL0__t199 WL0__t45 111.888796652
* device instance WL0_seg53 r0 *1 0,0
RWL0_seg53 WL0__t45 WL0__t192 60.1884561301
* device instance WL0_seg54 r0 *1 0,0
RWL0_seg54 WL0__t192 WL0__t47 111.888796652
* device instance WL0_seg55 r0 *1 0,0
RWL0_seg55 WL0__t47 WL0__t216 60.1884561301
* device instance WL0_seg56 r0 *1 0,0
RWL0_seg56 WL0__t216 WL0__t50 111.888796652
* device instance WL0_seg57 r0 *1 0,0
RWL0_seg57 WL0__t50 WL0__t207 60.1884561301
* device instance WL0_seg58 r0 *1 0,0
RWL0_seg58 WL0__t207 WL0__t52 111.888796652
* device instance WL0_seg59 r0 *1 0,0
RWL0_seg59 WL0__t52 WL0__t208 60.1884561301
* device instance WL0_seg60 r0 *1 0,0
RWL0_seg60 WL0__t208 WL0__t54 111.888796652
* device instance WL0_seg61 r0 *1 0,0
RWL0_seg61 WL0__t54 WL0__t212 60.1884561301
* device instance WL0_seg62 r0 *1 0,0
RWL0_seg62 WL0__t212 WL0__t48 111.888796652
* device instance WL0_seg63 r0 *1 0,0
RWL0_seg63 WL0__t48 WL0__t139 60.1884561301
* device instance WL0_seg64 r0 *1 0,0
RWL0_seg64 WL0__t139 WL0__t100 111.888796652
* device instance WL0_seg65 r0 *1 0,0
RWL0_seg65 WL0__t100 WL0__t141 60.1884561301
* device instance WL0_seg66 r0 *1 0,0
RWL0_seg66 WL0__t141 WL0__t101 111.888796652
* device instance WL0_seg67 r0 *1 0,0
RWL0_seg67 WL0__t101 WL0__t144 60.1884561301
* device instance WL0_seg68 r0 *1 0,0
RWL0_seg68 WL0__t144 WL0__t102 111.888796652
* device instance WL0_seg69 r0 *1 0,0
RWL0_seg69 WL0__t102 WL0__t149 60.1884561301
* device instance WL0_seg70 r0 *1 0,0
RWL0_seg70 WL0__t149 WL0__t103 111.888796652
* device instance WL0_seg71 r0 *1 0,0
RWL0_seg71 WL0__t103 WL0__t151 60.1884561301
* device instance WL0_seg72 r0 *1 0,0
RWL0_seg72 WL0__t151 WL0__t104 111.888796652
* device instance WL0_seg73 r0 *1 0,0
RWL0_seg73 WL0__t104 WL0__t150 60.1884561301
* device instance WL0_seg74 r0 *1 0,0
RWL0_seg74 WL0__t150 WL0__t105 111.888796652
* device instance WL0_seg75 r0 *1 0,0
RWL0_seg75 WL0__t105 WL0__t135 60.1884561301
* device instance WL0_seg76 r0 *1 0,0
RWL0_seg76 WL0__t135 WL0__t106 111.888796652
* device instance WL0_seg77 r0 *1 0,0
RWL0_seg77 WL0__t106 WL0__t174 60.1884561301
* device instance WL0_seg78 r0 *1 0,0
RWL0_seg78 WL0__t174 WL0__t107 111.888796652
* device instance WL0_seg79 r0 *1 0,0
RWL0_seg79 WL0__t107 WL0__t236 60.1884561301
* device instance WL0_seg80 r0 *1 0,0
RWL0_seg80 WL0__t236 WL0__t96 111.888796652
* device instance WL0_seg81 r0 *1 0,0
RWL0_seg81 WL0__t96 WL0__t226 60.1884561301
* device instance WL0_seg82 r0 *1 0,0
RWL0_seg82 WL0__t226 WL0__t62 111.888796652
* device instance WL0_seg83 r0 *1 0,0
RWL0_seg83 WL0__t62 WL0__t247 60.1884561301
* device instance WL0_seg84 r0 *1 0,0
RWL0_seg84 WL0__t247 WL0__t67 111.888796652
* device instance WL0_seg85 r0 *1 0,0
RWL0_seg85 WL0__t67 WL0__t200 60.1884561301
* device instance WL0_seg86 r0 *1 0,0
RWL0_seg86 WL0__t200 WL0__t72 111.888796652
* device instance WL0_seg87 r0 *1 0,0
RWL0_seg87 WL0__t72 WL0__t189 60.1884561301
* device instance WL0_seg88 r0 *1 0,0
RWL0_seg88 WL0__t189 WL0__t77 111.888796652
* device instance WL0_seg89 r0 *1 0,0
RWL0_seg89 WL0__t77 WL0__t211 60.1884561301
* device instance WL0_seg90 r0 *1 0,0
RWL0_seg90 WL0__t211 WL0__t82 111.888796652
* device instance WL0_seg91 r0 *1 0,0
RWL0_seg91 WL0__t82 WL0__t220 60.1884561301
* device instance WL0_seg92 r0 *1 0,0
RWL0_seg92 WL0__t220 WL0__t116 111.888796652
* device instance WL0_seg93 r0 *1 0,0
RWL0_seg93 WL0__t116 WL0__t246 60.1884561301
* device instance WL0_seg94 r0 *1 0,0
RWL0_seg94 WL0__t246 WL0__t121 111.888796652
* device instance WL0_seg95 r0 *1 0,0
RWL0_seg95 WL0__t121 WL0__t185 60.1884561301
* device instance WL0_seg96 r0 *1 0,0
RWL0_seg96 WL0__t185 WL0__t91 111.888796652
* device instance WL0_seg97 r0 *1 0,0
RWL0_seg97 WL0__t91 WL0__t187 60.1884561301
* device instance WL0_seg98 r0 *1 0,0
RWL0_seg98 WL0__t187 WL0__t90 111.888796652
* device instance WL0_seg99 r0 *1 0,0
RWL0_seg99 WL0__t90 WL0__t155 60.1884561301
* device instance WL0_seg100 r0 *1 0,0
RWL0_seg100 WL0__t155 WL0__t89 111.888796652
* device instance WL0_seg101 r0 *1 0,0
RWL0_seg101 WL0__t89 WL0__t159 60.1884561301
* device instance WL0_seg102 r0 *1 0,0
RWL0_seg102 WL0__t159 WL0__t87 111.888796652
* device instance WL0_seg103 r0 *1 0,0
RWL0_seg103 WL0__t87 WL0__t163 60.1884561301
* device instance WL0_seg104 r0 *1 0,0
RWL0_seg104 WL0__t163 WL0__t86 111.888796652
* device instance WL0_seg105 r0 *1 0,0
RWL0_seg105 WL0__t86 WL0__t166 60.1884561301
* device instance WL0_seg106 r0 *1 0,0
RWL0_seg106 WL0__t166 WL0__t85 111.888796652
* device instance WL0_seg107 r0 *1 0,0
RWL0_seg107 WL0__t85 WL0__t169 60.1884561301
* device instance WL0_seg108 r0 *1 0,0
RWL0_seg108 WL0__t169 WL0__t84 111.888796652
* device instance WL0_seg109 r0 *1 0,0
RWL0_seg109 WL0__t84 WL0__t171 60.1884561301
* device instance WL0_seg110 r0 *1 0,0
RWL0_seg110 WL0__t171 WL0__t88 111.888796652
* device instance WL0_seg111 r0 *1 0,0
RWL0_seg111 WL0__t88 WL0__t183 60.1884561301
* device instance WL0_seg112 r0 *1 0,0
RWL0_seg112 WL0__t183 WL0__t92 111.888796652
* device instance WL0_seg113 r0 *1 0,0
RWL0_seg113 WL0__t92 WL0__t181 60.1884561301
* device instance WL0_seg114 r0 *1 0,0
RWL0_seg114 WL0__t181 WL0__t93 111.888796652
* device instance WL0_seg115 r0 *1 0,0
RWL0_seg115 WL0__t93 WL0__t188 60.1884561301
* device instance WL0_seg116 r0 *1 0,0
RWL0_seg116 WL0__t188 WL0__t94 111.888796652
* device instance WL0_seg117 r0 *1 0,0
RWL0_seg117 WL0__t94 WL0__t175 60.1884561301
* device instance WL0_seg118 r0 *1 0,0
RWL0_seg118 WL0__t175 WL0__t95 111.888796652
* device instance WL0_seg119 r0 *1 0,0
RWL0_seg119 WL0__t95 WL0__t172 60.1884561301
* device instance WL0_seg120 r0 *1 0,0
RWL0_seg120 WL0__t172 WL0__t109 111.888796652
* device instance WL0_seg121 r0 *1 0,0
RWL0_seg121 WL0__t109 WL0__t145 60.1884561301
* device instance WL0_seg122 r0 *1 0,0
RWL0_seg122 WL0__t145 WL0__t97 111.888796652
* device instance WL0_seg123 r0 *1 0,0
RWL0_seg123 WL0__t97 WL0__t129 60.1884561301
* device instance WL0_seg124 r0 *1 0,0
RWL0_seg124 WL0__t129 WL0__t98 111.888796652
* device instance WL0_seg125 r0 *1 0,0
RWL0_seg125 WL0__t98 WL0__t132 60.1884561301
* device instance WL0_seg126 r0 *1 0,0
RWL0_seg126 WL0__t132 WL0__t99 111.888796652
* device instance WL0_seg127 r0 *1 0,0
RWL0_seg127 WL0__t99 WL0 60.1884561301
* device instance WL0_seg128 r0 *1 0,0
RWL0_seg128 WL0 WL0__t75 111.888796652
* device instance WL0_seg129 r0 *1 0,0
RWL0_seg129 WL0__t75 WL0__t193 60.1884561301
* device instance WL0_seg130 r0 *1 0,0
RWL0_seg130 WL0__t193 WL0__t74 111.888796652
* device instance WL0_seg131 r0 *1 0,0
RWL0_seg131 WL0__t74 WL0__t205 60.1884561301
* device instance WL0_seg132 r0 *1 0,0
RWL0_seg132 WL0__t205 WL0__t73 111.888796652
* device instance WL0_seg133 r0 *1 0,0
RWL0_seg133 WL0__t73 WL0__t198 60.1884561301
* device instance WL0_seg134 r0 *1 0,0
RWL0_seg134 WL0__t198 WL0__t71 111.888796652
* device instance WL0_seg135 r0 *1 0,0
RWL0_seg135 WL0__t71 WL0__t203 60.1884561301
* device instance WL0_seg136 r0 *1 0,0
RWL0_seg136 WL0__t203 WL0__t83 111.888796652
* device instance WL0_seg137 r0 *1 0,0
RWL0_seg137 WL0__t83 WL0__t239 60.1884561301
* device instance WL0_seg138 r0 *1 0,0
RWL0_seg138 WL0__t239 WL0__t69 111.888796652
* device instance WL0_seg139 r0 *1 0,0
RWL0_seg139 WL0__t69 WL0__t241 60.1884561301
* device instance WL0_seg140 r0 *1 0,0
RWL0_seg140 WL0__t241 WL0__t68 111.888796652
* device instance WL0_seg141 r0 *1 0,0
RWL0_seg141 WL0__t68 WL0__t244 60.1884561301
* device instance WL0_seg142 r0 *1 0,0
RWL0_seg142 WL0__t244 WL0__t122 111.888796652
* device instance WL0_seg143 r0 *1 0,0
RWL0_seg143 WL0__t122 WL0__t248 60.1884561301
* device instance WL0_seg144 r0 *1 0,0
RWL0_seg144 WL0__t248 WL0__t65 111.888796652
* device instance WL0_seg145 r0 *1 0,0
RWL0_seg145 WL0__t65 WL0__t251 60.1884561301
* device instance WL0_seg146 r0 *1 0,0
RWL0_seg146 WL0__t251 WL0__t64 111.888796652
* device instance WL0_seg147 r0 *1 0,0
RWL0_seg147 WL0__t64 WL0__t254 60.1884561301
* device instance WL0_seg148 r0 *1 0,0
RWL0_seg148 WL0__t254 WL0__t63 111.888796652
* device instance WL0_seg149 r0 *1 0,0
RWL0_seg149 WL0__t63 WL0__t225 60.1884561301
* device instance WL0_seg150 r0 *1 0,0
RWL0_seg150 WL0__t225 WL0__t61 111.888796652
* device instance WL0_seg151 r0 *1 0,0
RWL0_seg151 WL0__t61 WL0__t228 60.1884561301
* device instance WL0_seg152 r0 *1 0,0
RWL0_seg152 WL0__t228 WL0__t60 111.888796652
* device instance WL0_seg153 r0 *1 0,0
RWL0_seg153 WL0__t60 WL0__t238 60.1884561301
* device instance WL0_seg154 r0 *1 0,0
RWL0_seg154 WL0__t238 WL0__t59 111.888796652
* device instance WL0_seg155 r0 *1 0,0
RWL0_seg155 WL0__t59 WL0__t231 60.1884561301
* device instance WL0_seg156 r0 *1 0,0
RWL0_seg156 WL0__t231 WL0__t58 111.888796652
* device instance WL0_seg157 r0 *1 0,0
RWL0_seg157 WL0__t58 WL0__t196 60.1884561301
* device instance WL0_seg158 r0 *1 0,0
RWL0_seg158 WL0__t196 WL0__t108 111.888796652
* device instance WL0_seg159 r0 *1 0,0
RWL0_seg159 WL0__t108 WL0__t143 60.1884561301
* device instance WL0_seg160 r0 *1 0,0
RWL0_seg160 WL0__t143 WL0__t119 111.888796652
* device instance WL0_seg161 r0 *1 0,0
RWL0_seg161 WL0__t119 WL0__t153 60.1884561301
* device instance WL0_seg162 r0 *1 0,0
RWL0_seg162 WL0__t153 WL0__t123 111.888796652
* device instance WL0_seg163 r0 *1 0,0
RWL0_seg163 WL0__t123 WL0__t234 60.1884561301
* device instance WL0_seg164 r0 *1 0,0
RWL0_seg164 WL0__t234 WL0__t125 111.888796652
* device instance WL0_seg165 r0 *1 0,0
RWL0_seg165 WL0__t125 WL0__t229 60.1884561301
* device instance WL0_seg166 r0 *1 0,0
RWL0_seg166 WL0__t229 WL0__t128 111.888796652
* device instance WL0_seg167 r0 *1 0,0
RWL0_seg167 WL0__t128 WL0__t252 60.1884561301
* device instance WL0_seg168 r0 *1 0,0
RWL0_seg168 WL0__t252 WL0__t113 111.888796652
* device instance WL0_seg169 r0 *1 0,0
RWL0_seg169 WL0__t113 WL0__t243 60.1884561301
* device instance WL0_seg170 r0 *1 0,0
RWL0_seg170 WL0__t243 WL0__t110 111.888796652
* device instance WL0_seg171 r0 *1 0,0
RWL0_seg171 WL0__t110 WL0__t240 60.1884561301
* device instance WL0_seg172 r0 *1 0,0
RWL0_seg172 WL0__t240 WL0__t115 111.888796652
* device instance WL0_seg173 r0 *1 0,0
RWL0_seg173 WL0__t115 WL0__t194 60.1884561301
* device instance WL0_seg174 r0 *1 0,0
RWL0_seg174 WL0__t194 WL0__t118 111.888796652
* device instance WL0_seg175 r0 *1 0,0
RWL0_seg175 WL0__t118 WL0__t218 60.1884561301
* device instance WL0_seg176 r0 *1 0,0
RWL0_seg176 WL0__t218 WL0__t126 111.888796652
* device instance WL0_seg177 r0 *1 0,0
RWL0_seg177 WL0__t126 WL0__t210 60.1884561301
* device instance WL0_seg178 r0 *1 0,0
RWL0_seg178 WL0__t210 WL0__t124 111.888796652
* device instance WL0_seg179 r0 *1 0,0
RWL0_seg179 WL0__t124 WL0__t206 60.1884561301
* device instance WL0_seg180 r0 *1 0,0
RWL0_seg180 WL0__t206 WL0__t70 111.888796652
* device instance WL0_seg181 r0 *1 0,0
RWL0_seg181 WL0__t70 WL0__t209 60.1884561301
* device instance WL0_seg182 r0 *1 0,0
RWL0_seg182 WL0__t209 WL0__t81 111.888796652
* device instance WL0_seg183 r0 *1 0,0
RWL0_seg183 WL0__t81 WL0__t222 60.1884561301
* device instance WL0_seg184 r0 *1 0,0
RWL0_seg184 WL0__t222 WL0__t80 111.888796652
* device instance WL0_seg185 r0 *1 0,0
RWL0_seg185 WL0__t80 WL0__t214 60.1884561301
* device instance WL0_seg186 r0 *1 0,0
RWL0_seg186 WL0__t214 WL0__t79 111.888796652
* device instance WL0_seg187 r0 *1 0,0
RWL0_seg187 WL0__t79 WL0__t217 60.1884561301
* device instance WL0_seg188 r0 *1 0,0
RWL0_seg188 WL0__t217 WL0__t78 111.888796652
* device instance WL0_seg189 r0 *1 0,0
RWL0_seg189 WL0__t78 WL0__t221 60.1884561301
* device instance WL0_seg190 r0 *1 0,0
RWL0_seg190 WL0__t221 WL0__t76 111.888796652
* device instance WL0_seg191 r0 *1 0,0
RWL0_seg191 WL0__t76 WL0__t204 60.1884561301
* device instance WL0_seg192 r0 *1 0,0
RWL0_seg192 WL0__t204 WL0__t44 111.888796652
* device instance WL0_seg193 r0 *1 0,0
RWL0_seg193 WL0__t44 WL0__t255 60.1884561301
* device instance WL0_seg194 r0 *1 0,0
RWL0_seg194 WL0__t255 WL0__t41 111.888796652
* device instance WL0_seg195 r0 *1 0,0
RWL0_seg195 WL0__t41 WL0__t223 60.1884561301
* device instance WL0_seg196 r0 *1 0,0
RWL0_seg196 WL0__t223 WL0__t40 111.888796652
* device instance WL0_seg197 r0 *1 0,0
RWL0_seg197 WL0__t40 WL0__t232 60.1884561301
* device instance WL0_seg198 r0 *1 0,0
RWL0_seg198 WL0__t232 WL0__t7 111.888796652
* device instance WL0_seg199 r0 *1 0,0
RWL0_seg199 WL0__t7 WL0__t136 60.1884561301
* device instance WL0_seg200 r0 *1 0,0
RWL0_seg200 WL0__t136 WL0__t10 111.888796652
* device instance WL0_seg201 r0 *1 0,0
RWL0_seg201 WL0__t10 WL0__t146 60.1884561301
* device instance WL0_seg202 r0 *1 0,0
RWL0_seg202 WL0__t146 WL0__t19 111.888796652
* device instance WL0_seg203 r0 *1 0,0
RWL0_seg203 WL0__t19 WL0__t130 60.1884561301
* device instance WL0_seg204 r0 *1 0,0
RWL0_seg204 WL0__t130 WL0__t11 111.888796652
* device instance WL0_seg205 r0 *1 0,0
RWL0_seg205 WL0__t11 WL0__t176 60.1884561301
* device instance WL0_seg206 r0 *1 0,0
RWL0_seg206 WL0__t176 WL0__t4 111.888796652
* device instance WL0_seg207 r0 *1 0,0
RWL0_seg207 WL0__t4 WL0__t249 60.1884561301
* device instance WL0_seg208 r0 *1 0,0
RWL0_seg208 WL0__t249 WL0__t32 111.888796652
* device instance WL0_seg209 r0 *1 0,0
RWL0_seg209 WL0__t32 WL0__t245 60.1884561301
* device instance WL0_seg210 r0 *1 0,0
RWL0_seg210 WL0__t245 WL0__t34 111.888796652
* device instance WL0_seg211 r0 *1 0,0
RWL0_seg211 WL0__t34 WL0__t242 60.1884561301
* device instance WL0_seg212 r0 *1 0,0
RWL0_seg212 WL0__t242 WL0__t37 111.888796652
* device instance WL0_seg213 r0 *1 0,0
RWL0_seg213 WL0__t37 WL0__t230 60.1884561301
* device instance WL0_seg214 r0 *1 0,0
RWL0_seg214 WL0__t230 WL0__t36 111.888796652
* device instance WL0_seg215 r0 *1 0,0
RWL0_seg215 WL0__t36 WL0__t201 60.1884561301
* device instance WL0_seg216 r0 *1 0,0
RWL0_seg216 WL0__t201 WL0__t35 111.888796652
* device instance WL0_seg217 r0 *1 0,0
RWL0_seg217 WL0__t35 WL0__t197 60.1884561301
* device instance WL0_seg218 r0 *1 0,0
RWL0_seg218 WL0__t197 WL0__t33 111.888796652
* device instance WL0_seg219 r0 *1 0,0
RWL0_seg219 WL0__t33 WL0__t195 60.1884561301
* device instance WL0_seg220 r0 *1 0,0
RWL0_seg220 WL0__t195 WL0__t30 111.888796652
* device instance WL0_seg221 r0 *1 0,0
RWL0_seg221 WL0__t30 WL0__t191 60.1884561301
* device instance WL0_seg222 r0 *1 0,0
RWL0_seg222 WL0__t191 WL0__t27 111.888796652
* device instance WL0_seg223 r0 *1 0,0
RWL0_seg223 WL0__t27 WL0__t168 60.1884561301
* device instance WL0_seg224 r0 *1 0,0
RWL0_seg224 WL0__t168 WL0__t66 111.888796652
* device instance WL0_seg225 r0 *1 0,0
RWL0_seg225 WL0__t66 WL0__t167 60.1884561301
* device instance WL0_seg226 r0 *1 0,0
RWL0_seg226 WL0__t167 WL0__t18 111.888796652
* device instance WL0_seg227 r0 *1 0,0
RWL0_seg227 WL0__t18 WL0__t164 60.1884561301
* device instance WL0_seg228 r0 *1 0,0
RWL0_seg228 WL0__t164 WL0__t12 111.888796652
* device instance WL0_seg229 r0 *1 0,0
RWL0_seg229 WL0__t12 WL0__t160 60.1884561301
* device instance WL0_seg230 r0 *1 0,0
RWL0_seg230 WL0__t160 WL0__t49 111.888796652
* device instance WL0_seg231 r0 *1 0,0
RWL0_seg231 WL0__t49 WL0__t157 60.1884561301
* device instance WL0_seg232 r0 *1 0,0
RWL0_seg232 WL0__t157 WL0__t53 111.888796652
* device instance WL0_seg233 r0 *1 0,0
RWL0_seg233 WL0__t53 WL0__t179 60.1884561301
* device instance WL0_seg234 r0 *1 0,0
RWL0_seg234 WL0__t179 WL0__t26 111.888796652
* device instance WL0_seg235 r0 *1 0,0
RWL0_seg235 WL0__t26 WL0__t184 60.1884561301
* device instance WL0_seg236 r0 *1 0,0
RWL0_seg236 WL0__t184 WL0__t39 111.888796652
* device instance WL0_seg237 r0 *1 0,0
RWL0_seg237 WL0__t39 WL0__t180 60.1884561301
* device instance WL0_seg238 r0 *1 0,0
RWL0_seg238 WL0__t180 WL0__t55 111.888796652
* device instance WL0_seg239 r0 *1 0,0
RWL0_seg239 WL0__t55 WL0__t177 60.1884561301
* device instance WL0_seg240 r0 *1 0,0
RWL0_seg240 WL0__t177 WL0__t43 111.888796652
* device instance WL0_seg241 r0 *1 0,0
RWL0_seg241 WL0__t43 WL0__t173 60.1884561301
* device instance WL0_seg242 r0 *1 0,0
RWL0_seg242 WL0__t173 WL0__t14 111.888796652
* device instance WL0_seg243 r0 *1 0,0
RWL0_seg243 WL0__t14 WL0__t134 60.1884561301
* device instance WL0_seg244 r0 *1 0,0
RWL0_seg244 WL0__t134 WL0__t2 111.888796652
* device instance WL0_seg245 r0 *1 0,0
RWL0_seg245 WL0__t2 WL0__t131 60.1884561301
* device instance WL0_seg246 r0 *1 0,0
RWL0_seg246 WL0__t131 WL0__t16 111.888796652
* device instance WL0_seg247 r0 *1 0,0
RWL0_seg247 WL0__t16 WL0__t138 60.1884561301
* device instance WL0_seg248 r0 *1 0,0
RWL0_seg248 WL0__t138 WL0__t17 111.888796652
* device instance WL0_seg249 r0 *1 0,0
RWL0_seg249 WL0__t17 WL0__t142 60.1884561301
* device instance WL0_seg250 r0 *1 0,0
RWL0_seg250 WL0__t142 WL0__t20 111.888796652
* device instance WL0_seg251 r0 *1 0,0
RWL0_seg251 WL0__t20 WL0__t147 60.1884561301
* device instance WL0_seg252 r0 *1 0,0
RWL0_seg252 WL0__t147 WL0__t13 111.888796652
* device instance WL0_seg253 r0 *1 0,0
RWL0_seg253 WL0__t13 WL0__t152 60.1884561301
* device instance WL0_seg254 r0 *1 0,0
RWL0_seg254 WL0__t152 WL0__t3 111.888796652
* device instance cc__10_VSS r0 *1 0,0
Ccc__10_VSS \$10 VSS 7.862e-18
* device instance cc__100_VSS r0 *1 0,0
Ccc__100_VSS \$100 VSS 7.862e-18
* device instance cc__101_VSS r0 *1 0,0
Ccc__101_VSS \$101 VSS 7.862e-18
* device instance cc__102_VSS r0 *1 0,0
Ccc__102_VSS \$102 VSS 7.862e-18
* device instance cc__103_VSS r0 *1 0,0
Ccc__103_VSS \$103 VSS 7.862e-18
* device instance cc__104_VSS r0 *1 0,0
Ccc__104_VSS \$104 VSS 7.862e-18
* device instance cc__105_VSS r0 *1 0,0
Ccc__105_VSS \$105 VSS 7.862e-18
* device instance cc__106_VSS r0 *1 0,0
Ccc__106_VSS \$106 VSS 7.862e-18
* device instance cc__107_VSS r0 *1 0,0
Ccc__107_VSS \$107 VSS 7.862e-18
* device instance cc__108_VSS r0 *1 0,0
Ccc__108_VSS \$108 VSS 7.862e-18
* device instance cc__109_VSS r0 *1 0,0
Ccc__109_VSS \$109 VSS 7.862e-18
* device instance cc__11_VSS r0 *1 0,0
Ccc__11_VSS \$11 VSS 7.862e-18
* device instance cc__110_VSS r0 *1 0,0
Ccc__110_VSS \$110 VSS 7.862e-18
* device instance cc__111_VSS r0 *1 0,0
Ccc__111_VSS \$111 VSS 7.862e-18
* device instance cc__112_VSS r0 *1 0,0
Ccc__112_VSS \$112 VSS 7.862e-18
* device instance cc__113_VSS r0 *1 0,0
Ccc__113_VSS \$113 VSS 7.862e-18
* device instance cc__114_VSS r0 *1 0,0
Ccc__114_VSS \$114 VSS 7.862e-18
* device instance cc__115_VSS r0 *1 0,0
Ccc__115_VSS \$115 VSS 7.862e-18
* device instance cc__116_VSS r0 *1 0,0
Ccc__116_VSS \$116 VSS 7.862e-18
* device instance cc__117_VSS r0 *1 0,0
Ccc__117_VSS \$117 VSS 7.862e-18
* device instance cc__118_VSS r0 *1 0,0
Ccc__118_VSS \$118 VSS 7.862e-18
* device instance cc__119_VSS r0 *1 0,0
Ccc__119_VSS \$119 VSS 7.862e-18
* device instance cc__12_VSS r0 *1 0,0
Ccc__12_VSS \$12 VSS 7.862e-18
* device instance cc__120_VSS r0 *1 0,0
Ccc__120_VSS \$120 VSS 7.862e-18
* device instance cc__121_VSS r0 *1 0,0
Ccc__121_VSS \$121 VSS 7.862e-18
* device instance cc__122_VSS r0 *1 0,0
Ccc__122_VSS \$122 VSS 7.862e-18
* device instance cc__123_VSS r0 *1 0,0
Ccc__123_VSS \$123 VSS 7.862e-18
* device instance cc__124_VSS r0 *1 0,0
Ccc__124_VSS \$124 VSS 7.862e-18
* device instance cc__125_VSS r0 *1 0,0
Ccc__125_VSS \$125 VSS 7.862e-18
* device instance cc__126_VSS r0 *1 0,0
Ccc__126_VSS \$126 VSS 7.862e-18
* device instance cc__127_VSS r0 *1 0,0
Ccc__127_VSS \$127 VSS 7.862e-18
* device instance cc__128_VSS r0 *1 0,0
Ccc__128_VSS \$128 VSS 7.862e-18
* device instance cc__129_VSS r0 *1 0,0
Ccc__129_VSS \$129 VSS 7.862e-18
* device instance cc__13_VSS r0 *1 0,0
Ccc__13_VSS \$13 VSS 7.862e-18
* device instance cc__130_VSS r0 *1 0,0
Ccc__130_VSS \$130 VSS 7.862e-18
* device instance cc__131_VSS r0 *1 0,0
Ccc__131_VSS \$131 VSS 7.862e-18
* device instance cc__133_VDD r0 *1 0,0
Ccc__133_VDD \$133 VDD 1.6433e-17
* device instance cc__133_VSS r0 *1 0,0
Ccc__133_VSS \$133 VSS 7.862e-18
* device instance cc__136_VDD r0 *1 0,0
Ccc__136_VDD \$136 VDD 1.6433e-17
* device instance cc__136_VSS r0 *1 0,0
Ccc__136_VSS \$136 VSS 7.862e-18
* device instance cc__139_VDD r0 *1 0,0
Ccc__139_VDD \$139 VDD 1.6433e-17
* device instance cc__139_VSS r0 *1 0,0
Ccc__139_VSS \$139 VSS 7.862e-18
* device instance cc__14_VSS r0 *1 0,0
Ccc__14_VSS \$14 VSS 7.862e-18
* device instance cc__142_VDD r0 *1 0,0
Ccc__142_VDD \$142 VDD 1.6433e-17
* device instance cc__142_VSS r0 *1 0,0
Ccc__142_VSS \$142 VSS 7.862e-18
* device instance cc__145_VDD r0 *1 0,0
Ccc__145_VDD \$145 VDD 1.6433e-17
* device instance cc__145_VSS r0 *1 0,0
Ccc__145_VSS \$145 VSS 7.862e-18
* device instance cc__148_VDD r0 *1 0,0
Ccc__148_VDD \$148 VDD 1.6433e-17
* device instance cc__148_VSS r0 *1 0,0
Ccc__148_VSS \$148 VSS 7.862e-18
* device instance cc__15_VSS r0 *1 0,0
Ccc__15_VSS \$15 VSS 7.862e-18
* device instance cc__151_VDD r0 *1 0,0
Ccc__151_VDD \$151 VDD 1.6433e-17
* device instance cc__151_VSS r0 *1 0,0
Ccc__151_VSS \$151 VSS 7.862e-18
* device instance cc__154_VDD r0 *1 0,0
Ccc__154_VDD \$154 VDD 1.6433e-17
* device instance cc__154_VSS r0 *1 0,0
Ccc__154_VSS \$154 VSS 7.862e-18
* device instance cc__157_VDD r0 *1 0,0
Ccc__157_VDD \$157 VDD 1.6433e-17
* device instance cc__157_VSS r0 *1 0,0
Ccc__157_VSS \$157 VSS 7.862e-18
* device instance cc__16_VSS r0 *1 0,0
Ccc__16_VSS \$16 VSS 7.862e-18
* device instance cc__160_VDD r0 *1 0,0
Ccc__160_VDD \$160 VDD 1.6433e-17
* device instance cc__160_VSS r0 *1 0,0
Ccc__160_VSS \$160 VSS 7.862e-18
* device instance cc__163_VDD r0 *1 0,0
Ccc__163_VDD \$163 VDD 1.6433e-17
* device instance cc__163_VSS r0 *1 0,0
Ccc__163_VSS \$163 VSS 7.862e-18
* device instance cc__166_VDD r0 *1 0,0
Ccc__166_VDD \$166 VDD 1.6433e-17
* device instance cc__166_VSS r0 *1 0,0
Ccc__166_VSS \$166 VSS 7.862e-18
* device instance cc__169_VDD r0 *1 0,0
Ccc__169_VDD \$169 VDD 1.6433e-17
* device instance cc__169_VSS r0 *1 0,0
Ccc__169_VSS \$169 VSS 7.862e-18
* device instance cc__17_VSS r0 *1 0,0
Ccc__17_VSS \$17 VSS 7.862e-18
* device instance cc__172_VDD r0 *1 0,0
Ccc__172_VDD \$172 VDD 1.6433e-17
* device instance cc__172_VSS r0 *1 0,0
Ccc__172_VSS \$172 VSS 7.862e-18
* device instance cc__175_VDD r0 *1 0,0
Ccc__175_VDD \$175 VDD 1.6433e-17
* device instance cc__175_VSS r0 *1 0,0
Ccc__175_VSS \$175 VSS 7.862e-18
* device instance cc__178_VDD r0 *1 0,0
Ccc__178_VDD \$178 VDD 1.6433e-17
* device instance cc__178_VSS r0 *1 0,0
Ccc__178_VSS \$178 VSS 7.862e-18
* device instance cc__18_VSS r0 *1 0,0
Ccc__18_VSS \$18 VSS 7.862e-18
* device instance cc__181_VDD r0 *1 0,0
Ccc__181_VDD \$181 VDD 1.6433e-17
* device instance cc__181_VSS r0 *1 0,0
Ccc__181_VSS \$181 VSS 7.862e-18
* device instance cc__184_VDD r0 *1 0,0
Ccc__184_VDD \$184 VDD 1.6433e-17
* device instance cc__184_VSS r0 *1 0,0
Ccc__184_VSS \$184 VSS 7.862e-18
* device instance cc__187_VDD r0 *1 0,0
Ccc__187_VDD \$187 VDD 1.6433e-17
* device instance cc__187_VSS r0 *1 0,0
Ccc__187_VSS \$187 VSS 7.862e-18
* device instance cc__19_VSS r0 *1 0,0
Ccc__19_VSS \$19 VSS 7.862e-18
* device instance cc__190_VDD r0 *1 0,0
Ccc__190_VDD \$190 VDD 1.6433e-17
* device instance cc__190_VSS r0 *1 0,0
Ccc__190_VSS \$190 VSS 7.862e-18
* device instance cc__193_VDD r0 *1 0,0
Ccc__193_VDD \$193 VDD 1.6433e-17
* device instance cc__193_VSS r0 *1 0,0
Ccc__193_VSS \$193 VSS 7.862e-18
* device instance cc__196_VDD r0 *1 0,0
Ccc__196_VDD \$196 VDD 1.6433e-17
* device instance cc__196_VSS r0 *1 0,0
Ccc__196_VSS \$196 VSS 7.862e-18
* device instance cc__199_VDD r0 *1 0,0
Ccc__199_VDD \$199 VDD 1.6433e-17
* device instance cc__199_VSS r0 *1 0,0
Ccc__199_VSS \$199 VSS 7.862e-18
* device instance cc__20_VSS r0 *1 0,0
Ccc__20_VSS \$20 VSS 7.862e-18
* device instance cc__202_VDD r0 *1 0,0
Ccc__202_VDD \$202 VDD 1.6433e-17
* device instance cc__202_VSS r0 *1 0,0
Ccc__202_VSS \$202 VSS 7.862e-18
* device instance cc__205_VDD r0 *1 0,0
Ccc__205_VDD \$205 VDD 1.6433e-17
* device instance cc__205_VSS r0 *1 0,0
Ccc__205_VSS \$205 VSS 7.862e-18
* device instance cc__208_VDD r0 *1 0,0
Ccc__208_VDD \$208 VDD 1.6433e-17
* device instance cc__208_VSS r0 *1 0,0
Ccc__208_VSS \$208 VSS 7.862e-18
* device instance cc__21_VSS r0 *1 0,0
Ccc__21_VSS \$21 VSS 7.862e-18
* device instance cc__211_VDD r0 *1 0,0
Ccc__211_VDD \$211 VDD 1.6433e-17
* device instance cc__211_VSS r0 *1 0,0
Ccc__211_VSS \$211 VSS 7.862e-18
* device instance cc__214_VDD r0 *1 0,0
Ccc__214_VDD \$214 VDD 1.6433e-17
* device instance cc__214_VSS r0 *1 0,0
Ccc__214_VSS \$214 VSS 7.862e-18
* device instance cc__217_VDD r0 *1 0,0
Ccc__217_VDD \$217 VDD 1.6433e-17
* device instance cc__217_VSS r0 *1 0,0
Ccc__217_VSS \$217 VSS 7.862e-18
* device instance cc__22_VSS r0 *1 0,0
Ccc__22_VSS \$22 VSS 7.862e-18
* device instance cc__220_VDD r0 *1 0,0
Ccc__220_VDD \$220 VDD 1.6433e-17
* device instance cc__220_VSS r0 *1 0,0
Ccc__220_VSS \$220 VSS 7.862e-18
* device instance cc__223_VDD r0 *1 0,0
Ccc__223_VDD \$223 VDD 1.6433e-17
* device instance cc__223_VSS r0 *1 0,0
Ccc__223_VSS \$223 VSS 7.862e-18
* device instance cc__226_VDD r0 *1 0,0
Ccc__226_VDD \$226 VDD 1.6433e-17
* device instance cc__226_VSS r0 *1 0,0
Ccc__226_VSS \$226 VSS 7.862e-18
* device instance cc__229_VDD r0 *1 0,0
Ccc__229_VDD \$229 VDD 1.6433e-17
* device instance cc__229_VSS r0 *1 0,0
Ccc__229_VSS \$229 VSS 7.862e-18
* device instance cc__23_VSS r0 *1 0,0
Ccc__23_VSS \$23 VSS 7.862e-18
* device instance cc__232_VDD r0 *1 0,0
Ccc__232_VDD \$232 VDD 1.6433e-17
* device instance cc__232_VSS r0 *1 0,0
Ccc__232_VSS \$232 VSS 7.862e-18
* device instance cc__235_VDD r0 *1 0,0
Ccc__235_VDD \$235 VDD 1.6433e-17
* device instance cc__235_VSS r0 *1 0,0
Ccc__235_VSS \$235 VSS 7.862e-18
* device instance cc__238_VDD r0 *1 0,0
Ccc__238_VDD \$238 VDD 1.6433e-17
* device instance cc__238_VSS r0 *1 0,0
Ccc__238_VSS \$238 VSS 7.862e-18
* device instance cc__24_VSS r0 *1 0,0
Ccc__24_VSS \$24 VSS 7.862e-18
* device instance cc__241_VDD r0 *1 0,0
Ccc__241_VDD \$241 VDD 1.6433e-17
* device instance cc__241_VSS r0 *1 0,0
Ccc__241_VSS \$241 VSS 7.862e-18
* device instance cc__244_VDD r0 *1 0,0
Ccc__244_VDD \$244 VDD 1.6433e-17
* device instance cc__244_VSS r0 *1 0,0
Ccc__244_VSS \$244 VSS 7.862e-18
* device instance cc__247_VDD r0 *1 0,0
Ccc__247_VDD \$247 VDD 1.6433e-17
* device instance cc__247_VSS r0 *1 0,0
Ccc__247_VSS \$247 VSS 7.862e-18
* device instance cc__25_VSS r0 *1 0,0
Ccc__25_VSS \$25 VSS 7.862e-18
* device instance cc__250_VDD r0 *1 0,0
Ccc__250_VDD \$250 VDD 1.6433e-17
* device instance cc__250_VSS r0 *1 0,0
Ccc__250_VSS \$250 VSS 7.862e-18
* device instance cc__253_VDD r0 *1 0,0
Ccc__253_VDD \$253 VDD 1.6433e-17
* device instance cc__253_VSS r0 *1 0,0
Ccc__253_VSS \$253 VSS 7.862e-18
* device instance cc__256_VDD r0 *1 0,0
Ccc__256_VDD \$256 VDD 1.6433e-17
* device instance cc__256_VSS r0 *1 0,0
Ccc__256_VSS \$256 VSS 7.862e-18
* device instance cc__259_VDD r0 *1 0,0
Ccc__259_VDD \$259 VDD 1.6433e-17
* device instance cc__259_VSS r0 *1 0,0
Ccc__259_VSS \$259 VSS 7.862e-18
* device instance cc__26_VSS r0 *1 0,0
Ccc__26_VSS \$26 VSS 7.862e-18
* device instance cc__262_VDD r0 *1 0,0
Ccc__262_VDD \$262 VDD 1.6433e-17
* device instance cc__262_VSS r0 *1 0,0
Ccc__262_VSS \$262 VSS 7.862e-18
* device instance cc__265_VDD r0 *1 0,0
Ccc__265_VDD \$265 VDD 1.6433e-17
* device instance cc__265_VSS r0 *1 0,0
Ccc__265_VSS \$265 VSS 7.862e-18
* device instance cc__268_VDD r0 *1 0,0
Ccc__268_VDD \$268 VDD 1.6433e-17
* device instance cc__268_VSS r0 *1 0,0
Ccc__268_VSS \$268 VSS 7.862e-18
* device instance cc__27_VSS r0 *1 0,0
Ccc__27_VSS \$27 VSS 7.862e-18
* device instance cc__271_VDD r0 *1 0,0
Ccc__271_VDD \$271 VDD 1.6433e-17
* device instance cc__271_VSS r0 *1 0,0
Ccc__271_VSS \$271 VSS 7.862e-18
* device instance cc__274_VDD r0 *1 0,0
Ccc__274_VDD \$274 VDD 1.6433e-17
* device instance cc__274_VSS r0 *1 0,0
Ccc__274_VSS \$274 VSS 7.862e-18
* device instance cc__277_VDD r0 *1 0,0
Ccc__277_VDD \$277 VDD 1.6433e-17
* device instance cc__277_VSS r0 *1 0,0
Ccc__277_VSS \$277 VSS 7.862e-18
* device instance cc__28_VSS r0 *1 0,0
Ccc__28_VSS \$28 VSS 7.862e-18
* device instance cc__280_VDD r0 *1 0,0
Ccc__280_VDD \$280 VDD 1.6433e-17
* device instance cc__280_VSS r0 *1 0,0
Ccc__280_VSS \$280 VSS 7.862e-18
* device instance cc__283_VDD r0 *1 0,0
Ccc__283_VDD \$283 VDD 1.6433e-17
* device instance cc__283_VSS r0 *1 0,0
Ccc__283_VSS \$283 VSS 7.862e-18
* device instance cc__286_VDD r0 *1 0,0
Ccc__286_VDD \$286 VDD 1.6433e-17
* device instance cc__286_VSS r0 *1 0,0
Ccc__286_VSS \$286 VSS 7.862e-18
* device instance cc__289_VDD r0 *1 0,0
Ccc__289_VDD \$289 VDD 1.6433e-17
* device instance cc__289_VSS r0 *1 0,0
Ccc__289_VSS \$289 VSS 7.862e-18
* device instance cc__29_VSS r0 *1 0,0
Ccc__29_VSS \$29 VSS 7.862e-18
* device instance cc__292_VDD r0 *1 0,0
Ccc__292_VDD \$292 VDD 1.6433e-17
* device instance cc__292_VSS r0 *1 0,0
Ccc__292_VSS \$292 VSS 7.862e-18
* device instance cc__295_VDD r0 *1 0,0
Ccc__295_VDD \$295 VDD 1.6433e-17
* device instance cc__295_VSS r0 *1 0,0
Ccc__295_VSS \$295 VSS 7.862e-18
* device instance cc__298_VDD r0 *1 0,0
Ccc__298_VDD \$298 VDD 1.6433e-17
* device instance cc__298_VSS r0 *1 0,0
Ccc__298_VSS \$298 VSS 7.862e-18
* device instance cc__30_VSS r0 *1 0,0
Ccc__30_VSS \$30 VSS 7.862e-18
* device instance cc__301_VDD r0 *1 0,0
Ccc__301_VDD \$301 VDD 1.6433e-17
* device instance cc__301_VSS r0 *1 0,0
Ccc__301_VSS \$301 VSS 7.862e-18
* device instance cc__304_VDD r0 *1 0,0
Ccc__304_VDD \$304 VDD 1.6433e-17
* device instance cc__304_VSS r0 *1 0,0
Ccc__304_VSS \$304 VSS 7.862e-18
* device instance cc__307_VDD r0 *1 0,0
Ccc__307_VDD \$307 VDD 1.6433e-17
* device instance cc__307_VSS r0 *1 0,0
Ccc__307_VSS \$307 VSS 7.862e-18
* device instance cc__31_VSS r0 *1 0,0
Ccc__31_VSS \$31 VSS 7.862e-18
* device instance cc__310_VDD r0 *1 0,0
Ccc__310_VDD \$310 VDD 1.6433e-17
* device instance cc__310_VSS r0 *1 0,0
Ccc__310_VSS \$310 VSS 7.862e-18
* device instance cc__313_VDD r0 *1 0,0
Ccc__313_VDD \$313 VDD 1.6433e-17
* device instance cc__313_VSS r0 *1 0,0
Ccc__313_VSS \$313 VSS 7.862e-18
* device instance cc__316_VDD r0 *1 0,0
Ccc__316_VDD \$316 VDD 1.6433e-17
* device instance cc__316_VSS r0 *1 0,0
Ccc__316_VSS \$316 VSS 7.862e-18
* device instance cc__319_VDD r0 *1 0,0
Ccc__319_VDD \$319 VDD 1.6433e-17
* device instance cc__319_VSS r0 *1 0,0
Ccc__319_VSS \$319 VSS 7.862e-18
* device instance cc__32_VSS r0 *1 0,0
Ccc__32_VSS \$32 VSS 7.862e-18
* device instance cc__322_VDD r0 *1 0,0
Ccc__322_VDD \$322 VDD 1.6433e-17
* device instance cc__322_VSS r0 *1 0,0
Ccc__322_VSS \$322 VSS 7.862e-18
* device instance cc__325_VDD r0 *1 0,0
Ccc__325_VDD \$325 VDD 1.6433e-17
* device instance cc__325_VSS r0 *1 0,0
Ccc__325_VSS \$325 VSS 7.862e-18
* device instance cc__328_VDD r0 *1 0,0
Ccc__328_VDD \$328 VDD 1.6433e-17
* device instance cc__328_VSS r0 *1 0,0
Ccc__328_VSS \$328 VSS 7.862e-18
* device instance cc__33_VSS r0 *1 0,0
Ccc__33_VSS \$33 VSS 7.862e-18
* device instance cc__331_VDD r0 *1 0,0
Ccc__331_VDD \$331 VDD 1.6433e-17
* device instance cc__331_VSS r0 *1 0,0
Ccc__331_VSS \$331 VSS 7.862e-18
* device instance cc__334_VDD r0 *1 0,0
Ccc__334_VDD \$334 VDD 1.6433e-17
* device instance cc__334_VSS r0 *1 0,0
Ccc__334_VSS \$334 VSS 7.862e-18
* device instance cc__337_VDD r0 *1 0,0
Ccc__337_VDD \$337 VDD 1.6433e-17
* device instance cc__337_VSS r0 *1 0,0
Ccc__337_VSS \$337 VSS 7.862e-18
* device instance cc__34_VSS r0 *1 0,0
Ccc__34_VSS \$34 VSS 7.862e-18
* device instance cc__340_VDD r0 *1 0,0
Ccc__340_VDD \$340 VDD 1.6433e-17
* device instance cc__340_VSS r0 *1 0,0
Ccc__340_VSS \$340 VSS 7.862e-18
* device instance cc__343_VDD r0 *1 0,0
Ccc__343_VDD \$343 VDD 1.6433e-17
* device instance cc__343_VSS r0 *1 0,0
Ccc__343_VSS \$343 VSS 7.862e-18
* device instance cc__346_VDD r0 *1 0,0
Ccc__346_VDD \$346 VDD 1.6433e-17
* device instance cc__346_VSS r0 *1 0,0
Ccc__346_VSS \$346 VSS 7.862e-18
* device instance cc__349_VDD r0 *1 0,0
Ccc__349_VDD \$349 VDD 1.6433e-17
* device instance cc__349_VSS r0 *1 0,0
Ccc__349_VSS \$349 VSS 7.862e-18
* device instance cc__35_VSS r0 *1 0,0
Ccc__35_VSS \$35 VSS 7.862e-18
* device instance cc__352_VDD r0 *1 0,0
Ccc__352_VDD \$352 VDD 1.6433e-17
* device instance cc__352_VSS r0 *1 0,0
Ccc__352_VSS \$352 VSS 7.862e-18
* device instance cc__355_VDD r0 *1 0,0
Ccc__355_VDD \$355 VDD 1.6433e-17
* device instance cc__355_VSS r0 *1 0,0
Ccc__355_VSS \$355 VSS 7.862e-18
* device instance cc__358_VDD r0 *1 0,0
Ccc__358_VDD \$358 VDD 1.6433e-17
* device instance cc__358_VSS r0 *1 0,0
Ccc__358_VSS \$358 VSS 7.862e-18
* device instance cc__36_VSS r0 *1 0,0
Ccc__36_VSS \$36 VSS 7.862e-18
* device instance cc__361_VDD r0 *1 0,0
Ccc__361_VDD \$361 VDD 1.6433e-17
* device instance cc__361_VSS r0 *1 0,0
Ccc__361_VSS \$361 VSS 7.862e-18
* device instance cc__364_VDD r0 *1 0,0
Ccc__364_VDD \$364 VDD 1.6433e-17
* device instance cc__364_VSS r0 *1 0,0
Ccc__364_VSS \$364 VSS 7.862e-18
* device instance cc__367_VDD r0 *1 0,0
Ccc__367_VDD \$367 VDD 1.6433e-17
* device instance cc__367_VSS r0 *1 0,0
Ccc__367_VSS \$367 VSS 7.862e-18
* device instance cc__37_VSS r0 *1 0,0
Ccc__37_VSS \$37 VSS 7.862e-18
* device instance cc__370_VDD r0 *1 0,0
Ccc__370_VDD \$370 VDD 1.6433e-17
* device instance cc__370_VSS r0 *1 0,0
Ccc__370_VSS \$370 VSS 7.862e-18
* device instance cc__373_VDD r0 *1 0,0
Ccc__373_VDD \$373 VDD 1.6433e-17
* device instance cc__373_VSS r0 *1 0,0
Ccc__373_VSS \$373 VSS 7.862e-18
* device instance cc__376_VDD r0 *1 0,0
Ccc__376_VDD \$376 VDD 1.6433e-17
* device instance cc__376_VSS r0 *1 0,0
Ccc__376_VSS \$376 VSS 7.862e-18
* device instance cc__379_VDD r0 *1 0,0
Ccc__379_VDD \$379 VDD 1.6433e-17
* device instance cc__379_VSS r0 *1 0,0
Ccc__379_VSS \$379 VSS 7.862e-18
* device instance cc__38_VSS r0 *1 0,0
Ccc__38_VSS \$38 VSS 7.862e-18
* device instance cc__382_VDD r0 *1 0,0
Ccc__382_VDD \$382 VDD 1.6433e-17
* device instance cc__382_VSS r0 *1 0,0
Ccc__382_VSS \$382 VSS 7.862e-18
* device instance cc__385_VDD r0 *1 0,0
Ccc__385_VDD \$385 VDD 1.6433e-17
* device instance cc__385_VSS r0 *1 0,0
Ccc__385_VSS \$385 VSS 7.862e-18
* device instance cc__388_VDD r0 *1 0,0
Ccc__388_VDD \$388 VDD 1.6433e-17
* device instance cc__388_VSS r0 *1 0,0
Ccc__388_VSS \$388 VSS 7.862e-18
* device instance cc__39_VSS r0 *1 0,0
Ccc__39_VSS \$39 VSS 7.862e-18
* device instance cc__391_VDD r0 *1 0,0
Ccc__391_VDD \$391 VDD 1.6433e-17
* device instance cc__391_VSS r0 *1 0,0
Ccc__391_VSS \$391 VSS 7.862e-18
* device instance cc__394_VDD r0 *1 0,0
Ccc__394_VDD \$394 VDD 1.6433e-17
* device instance cc__394_VSS r0 *1 0,0
Ccc__394_VSS \$394 VSS 7.862e-18
* device instance cc__397_VDD r0 *1 0,0
Ccc__397_VDD \$397 VDD 1.6433e-17
* device instance cc__397_VSS r0 *1 0,0
Ccc__397_VSS \$397 VSS 7.862e-18
* device instance cc__4_VSS r0 *1 0,0
Ccc__4_VSS \$4 VSS 7.862e-18
* device instance cc__40_VSS r0 *1 0,0
Ccc__40_VSS \$40 VSS 7.862e-18
* device instance cc__400_VDD r0 *1 0,0
Ccc__400_VDD \$400 VDD 1.6433e-17
* device instance cc__400_VSS r0 *1 0,0
Ccc__400_VSS \$400 VSS 7.862e-18
* device instance cc__403_VDD r0 *1 0,0
Ccc__403_VDD \$403 VDD 1.6433e-17
* device instance cc__403_VSS r0 *1 0,0
Ccc__403_VSS \$403 VSS 7.862e-18
* device instance cc__406_VDD r0 *1 0,0
Ccc__406_VDD \$406 VDD 1.6433e-17
* device instance cc__406_VSS r0 *1 0,0
Ccc__406_VSS \$406 VSS 7.862e-18
* device instance cc__409_VDD r0 *1 0,0
Ccc__409_VDD \$409 VDD 1.6433e-17
* device instance cc__409_VSS r0 *1 0,0
Ccc__409_VSS \$409 VSS 7.862e-18
* device instance cc__41_VSS r0 *1 0,0
Ccc__41_VSS \$41 VSS 7.862e-18
* device instance cc__412_VDD r0 *1 0,0
Ccc__412_VDD \$412 VDD 1.6433e-17
* device instance cc__412_VSS r0 *1 0,0
Ccc__412_VSS \$412 VSS 7.862e-18
* device instance cc__415_VDD r0 *1 0,0
Ccc__415_VDD \$415 VDD 1.6433e-17
* device instance cc__415_VSS r0 *1 0,0
Ccc__415_VSS \$415 VSS 7.862e-18
* device instance cc__418_VDD r0 *1 0,0
Ccc__418_VDD \$418 VDD 1.6433e-17
* device instance cc__418_VSS r0 *1 0,0
Ccc__418_VSS \$418 VSS 7.862e-18
* device instance cc__42_VSS r0 *1 0,0
Ccc__42_VSS \$42 VSS 7.862e-18
* device instance cc__421_VDD r0 *1 0,0
Ccc__421_VDD \$421 VDD 1.6433e-17
* device instance cc__421_VSS r0 *1 0,0
Ccc__421_VSS \$421 VSS 7.862e-18
* device instance cc__424_VDD r0 *1 0,0
Ccc__424_VDD \$424 VDD 1.6433e-17
* device instance cc__424_VSS r0 *1 0,0
Ccc__424_VSS \$424 VSS 7.862e-18
* device instance cc__427_VDD r0 *1 0,0
Ccc__427_VDD \$427 VDD 1.6433e-17
* device instance cc__427_VSS r0 *1 0,0
Ccc__427_VSS \$427 VSS 7.862e-18
* device instance cc__43_VSS r0 *1 0,0
Ccc__43_VSS \$43 VSS 7.862e-18
* device instance cc__430_VDD r0 *1 0,0
Ccc__430_VDD \$430 VDD 1.6433e-17
* device instance cc__430_VSS r0 *1 0,0
Ccc__430_VSS \$430 VSS 7.862e-18
* device instance cc__433_VDD r0 *1 0,0
Ccc__433_VDD \$433 VDD 1.6433e-17
* device instance cc__433_VSS r0 *1 0,0
Ccc__433_VSS \$433 VSS 7.862e-18
* device instance cc__436_VDD r0 *1 0,0
Ccc__436_VDD \$436 VDD 1.6433e-17
* device instance cc__436_VSS r0 *1 0,0
Ccc__436_VSS \$436 VSS 7.862e-18
* device instance cc__439_VDD r0 *1 0,0
Ccc__439_VDD \$439 VDD 1.6433e-17
* device instance cc__439_VSS r0 *1 0,0
Ccc__439_VSS \$439 VSS 7.862e-18
* device instance cc__44_VSS r0 *1 0,0
Ccc__44_VSS \$44 VSS 7.862e-18
* device instance cc__442_VDD r0 *1 0,0
Ccc__442_VDD \$442 VDD 1.6433e-17
* device instance cc__442_VSS r0 *1 0,0
Ccc__442_VSS \$442 VSS 7.862e-18
* device instance cc__445_VDD r0 *1 0,0
Ccc__445_VDD \$445 VDD 1.6433e-17
* device instance cc__445_VSS r0 *1 0,0
Ccc__445_VSS \$445 VSS 7.862e-18
* device instance cc__448_VDD r0 *1 0,0
Ccc__448_VDD \$448 VDD 1.6433e-17
* device instance cc__448_VSS r0 *1 0,0
Ccc__448_VSS \$448 VSS 7.862e-18
* device instance cc__45_VSS r0 *1 0,0
Ccc__45_VSS \$45 VSS 7.862e-18
* device instance cc__451_VDD r0 *1 0,0
Ccc__451_VDD \$451 VDD 1.6433e-17
* device instance cc__451_VSS r0 *1 0,0
Ccc__451_VSS \$451 VSS 7.862e-18
* device instance cc__454_VDD r0 *1 0,0
Ccc__454_VDD \$454 VDD 1.6433e-17
* device instance cc__454_VSS r0 *1 0,0
Ccc__454_VSS \$454 VSS 7.862e-18
* device instance cc__457_VDD r0 *1 0,0
Ccc__457_VDD \$457 VDD 1.6433e-17
* device instance cc__457_VSS r0 *1 0,0
Ccc__457_VSS \$457 VSS 7.862e-18
* device instance cc__46_VSS r0 *1 0,0
Ccc__46_VSS \$46 VSS 7.862e-18
* device instance cc__460_VDD r0 *1 0,0
Ccc__460_VDD \$460 VDD 1.6433e-17
* device instance cc__460_VSS r0 *1 0,0
Ccc__460_VSS \$460 VSS 7.862e-18
* device instance cc__463_VDD r0 *1 0,0
Ccc__463_VDD \$463 VDD 1.6433e-17
* device instance cc__463_VSS r0 *1 0,0
Ccc__463_VSS \$463 VSS 7.862e-18
* device instance cc__466_VDD r0 *1 0,0
Ccc__466_VDD \$466 VDD 1.6433e-17
* device instance cc__466_VSS r0 *1 0,0
Ccc__466_VSS \$466 VSS 7.862e-18
* device instance cc__469_VDD r0 *1 0,0
Ccc__469_VDD \$469 VDD 1.6433e-17
* device instance cc__469_VSS r0 *1 0,0
Ccc__469_VSS \$469 VSS 7.862e-18
* device instance cc__47_VSS r0 *1 0,0
Ccc__47_VSS \$47 VSS 7.862e-18
* device instance cc__472_VDD r0 *1 0,0
Ccc__472_VDD \$472 VDD 1.6433e-17
* device instance cc__472_VSS r0 *1 0,0
Ccc__472_VSS \$472 VSS 7.862e-18
* device instance cc__475_VDD r0 *1 0,0
Ccc__475_VDD \$475 VDD 1.6433e-17
* device instance cc__475_VSS r0 *1 0,0
Ccc__475_VSS \$475 VSS 7.862e-18
* device instance cc__478_VDD r0 *1 0,0
Ccc__478_VDD \$478 VDD 1.6433e-17
* device instance cc__478_VSS r0 *1 0,0
Ccc__478_VSS \$478 VSS 7.862e-18
* device instance cc__48_VSS r0 *1 0,0
Ccc__48_VSS \$48 VSS 7.862e-18
* device instance cc__481_VDD r0 *1 0,0
Ccc__481_VDD \$481 VDD 1.6433e-17
* device instance cc__481_VSS r0 *1 0,0
Ccc__481_VSS \$481 VSS 7.862e-18
* device instance cc__484_VDD r0 *1 0,0
Ccc__484_VDD \$484 VDD 1.6433e-17
* device instance cc__484_VSS r0 *1 0,0
Ccc__484_VSS \$484 VSS 7.862e-18
* device instance cc__487_VDD r0 *1 0,0
Ccc__487_VDD \$487 VDD 1.6433e-17
* device instance cc__487_VSS r0 *1 0,0
Ccc__487_VSS \$487 VSS 7.862e-18
* device instance cc__49_VSS r0 *1 0,0
Ccc__49_VSS \$49 VSS 7.862e-18
* device instance cc__490_VDD r0 *1 0,0
Ccc__490_VDD \$490 VDD 1.6433e-17
* device instance cc__490_VSS r0 *1 0,0
Ccc__490_VSS \$490 VSS 7.862e-18
* device instance cc__493_VDD r0 *1 0,0
Ccc__493_VDD \$493 VDD 1.6433e-17
* device instance cc__493_VSS r0 *1 0,0
Ccc__493_VSS \$493 VSS 7.862e-18
* device instance cc__496_VDD r0 *1 0,0
Ccc__496_VDD \$496 VDD 1.6433e-17
* device instance cc__496_VSS r0 *1 0,0
Ccc__496_VSS \$496 VSS 7.862e-18
* device instance cc__499_VDD r0 *1 0,0
Ccc__499_VDD \$499 VDD 1.6433e-17
* device instance cc__499_VSS r0 *1 0,0
Ccc__499_VSS \$499 VSS 7.862e-18
* device instance cc__5_VSS r0 *1 0,0
Ccc__5_VSS \$5 VSS 7.862e-18
* device instance cc__50_VSS r0 *1 0,0
Ccc__50_VSS \$50 VSS 7.862e-18
* device instance cc__502_VDD r0 *1 0,0
Ccc__502_VDD \$502 VDD 1.6433e-17
* device instance cc__502_VSS r0 *1 0,0
Ccc__502_VSS \$502 VSS 7.862e-18
* device instance cc__505_VDD r0 *1 0,0
Ccc__505_VDD \$505 VDD 1.6433e-17
* device instance cc__505_VSS r0 *1 0,0
Ccc__505_VSS \$505 VSS 7.862e-18
* device instance cc__508_VDD r0 *1 0,0
Ccc__508_VDD \$508 VDD 1.6433e-17
* device instance cc__508_VSS r0 *1 0,0
Ccc__508_VSS \$508 VSS 7.862e-18
* device instance cc__51_VSS r0 *1 0,0
Ccc__51_VSS \$51 VSS 7.862e-18
* device instance cc__511_VDD r0 *1 0,0
Ccc__511_VDD \$511 VDD 1.6433e-17
* device instance cc__511_VSS r0 *1 0,0
Ccc__511_VSS \$511 VSS 7.862e-18
* device instance cc__514_VDD r0 *1 0,0
Ccc__514_VDD \$514 VDD 1.6433e-17
* device instance cc__514_VSS r0 *1 0,0
Ccc__514_VSS \$514 VSS 7.862e-18
* device instance cc__52_VSS r0 *1 0,0
Ccc__52_VSS \$52 VSS 7.862e-18
* device instance cc__53_VSS r0 *1 0,0
Ccc__53_VSS \$53 VSS 7.862e-18
* device instance cc__54_VSS r0 *1 0,0
Ccc__54_VSS \$54 VSS 7.862e-18
* device instance cc__55_VSS r0 *1 0,0
Ccc__55_VSS \$55 VSS 7.862e-18
* device instance cc__56_VSS r0 *1 0,0
Ccc__56_VSS \$56 VSS 7.862e-18
* device instance cc__57_VSS r0 *1 0,0
Ccc__57_VSS \$57 VSS 7.862e-18
* device instance cc__58_VSS r0 *1 0,0
Ccc__58_VSS \$58 VSS 7.862e-18
* device instance cc__59_VSS r0 *1 0,0
Ccc__59_VSS \$59 VSS 7.862e-18
* device instance cc__6_VSS r0 *1 0,0
Ccc__6_VSS \$6 VSS 7.862e-18
* device instance cc__60_VSS r0 *1 0,0
Ccc__60_VSS \$60 VSS 7.862e-18
* device instance cc__61_VSS r0 *1 0,0
Ccc__61_VSS \$61 VSS 7.862e-18
* device instance cc__62_VSS r0 *1 0,0
Ccc__62_VSS \$62 VSS 7.862e-18
* device instance cc__63_VSS r0 *1 0,0
Ccc__63_VSS \$63 VSS 7.862e-18
* device instance cc__64_VSS r0 *1 0,0
Ccc__64_VSS \$64 VSS 7.862e-18
* device instance cc__65_VSS r0 *1 0,0
Ccc__65_VSS \$65 VSS 7.862e-18
* device instance cc__66_VSS r0 *1 0,0
Ccc__66_VSS \$66 VSS 7.862e-18
* device instance cc__67_VSS r0 *1 0,0
Ccc__67_VSS \$67 VSS 7.862e-18
* device instance cc__68_VSS r0 *1 0,0
Ccc__68_VSS \$68 VSS 7.862e-18
* device instance cc__69_VSS r0 *1 0,0
Ccc__69_VSS \$69 VSS 7.862e-18
* device instance cc__7_VSS r0 *1 0,0
Ccc__7_VSS \$7 VSS 7.862e-18
* device instance cc__70_VSS r0 *1 0,0
Ccc__70_VSS \$70 VSS 7.862e-18
* device instance cc__71_VSS r0 *1 0,0
Ccc__71_VSS \$71 VSS 7.862e-18
* device instance cc__72_VSS r0 *1 0,0
Ccc__72_VSS \$72 VSS 7.862e-18
* device instance cc__73_VSS r0 *1 0,0
Ccc__73_VSS \$73 VSS 7.862e-18
* device instance cc__74_VSS r0 *1 0,0
Ccc__74_VSS \$74 VSS 7.862e-18
* device instance cc__75_VSS r0 *1 0,0
Ccc__75_VSS \$75 VSS 7.862e-18
* device instance cc__76_VSS r0 *1 0,0
Ccc__76_VSS \$76 VSS 7.862e-18
* device instance cc__77_VSS r0 *1 0,0
Ccc__77_VSS \$77 VSS 7.862e-18
* device instance cc__78_VSS r0 *1 0,0
Ccc__78_VSS \$78 VSS 7.862e-18
* device instance cc__79_VSS r0 *1 0,0
Ccc__79_VSS \$79 VSS 7.862e-18
* device instance cc__8_VSS r0 *1 0,0
Ccc__8_VSS \$8 VSS 7.862e-18
* device instance cc__80_VSS r0 *1 0,0
Ccc__80_VSS \$80 VSS 7.862e-18
* device instance cc__81_VSS r0 *1 0,0
Ccc__81_VSS \$81 VSS 7.862e-18
* device instance cc__82_VSS r0 *1 0,0
Ccc__82_VSS \$82 VSS 7.862e-18
* device instance cc__83_VSS r0 *1 0,0
Ccc__83_VSS \$83 VSS 7.862e-18
* device instance cc__84_VSS r0 *1 0,0
Ccc__84_VSS \$84 VSS 7.862e-18
* device instance cc__85_VSS r0 *1 0,0
Ccc__85_VSS \$85 VSS 7.862e-18
* device instance cc__86_VSS r0 *1 0,0
Ccc__86_VSS \$86 VSS 7.862e-18
* device instance cc__87_VSS r0 *1 0,0
Ccc__87_VSS \$87 VSS 7.862e-18
* device instance cc__88_VSS r0 *1 0,0
Ccc__88_VSS \$88 VSS 7.862e-18
* device instance cc__89_VSS r0 *1 0,0
Ccc__89_VSS \$89 VSS 7.862e-18
* device instance cc__9_VSS r0 *1 0,0
Ccc__9_VSS \$9 VSS 7.862e-18
* device instance cc__90_VSS r0 *1 0,0
Ccc__90_VSS \$90 VSS 7.862e-18
* device instance cc__91_VSS r0 *1 0,0
Ccc__91_VSS \$91 VSS 7.862e-18
* device instance cc__92_VSS r0 *1 0,0
Ccc__92_VSS \$92 VSS 7.862e-18
* device instance cc__93_VSS r0 *1 0,0
Ccc__93_VSS \$93 VSS 7.862e-18
* device instance cc__94_VSS r0 *1 0,0
Ccc__94_VSS \$94 VSS 7.862e-18
* device instance cc__95_VSS r0 *1 0,0
Ccc__95_VSS \$95 VSS 7.862e-18
* device instance cc__96_VSS r0 *1 0,0
Ccc__96_VSS \$96 VSS 7.862e-18
* device instance cc__97_VSS r0 *1 0,0
Ccc__97_VSS \$97 VSS 7.862e-18
* device instance cc__98_VSS r0 *1 0,0
Ccc__98_VSS \$98 VSS 7.862e-18
* device instance cc__99_VSS r0 *1 0,0
Ccc__99_VSS \$99 VSS 7.862e-18
* device instance cc_VDD_VSS r0 *1 0,0
Ccc_VDD_VSS VDD VSS 6.487115e-15
* device instance vsubs_dctie r0 *1 0,0
Rvsubs_dctie vsubs 0 1e+12
.ENDS wl_row_128
