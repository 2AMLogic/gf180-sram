* Hold SNM testbench -- bitcell_6t, decoupled half-cell fixture.
*
* Claim under test: spec/sram.md "Characterization" -- hold static noise
* margin (hold SNM), one of the four ratified measurements, swept across
* the 27-corner PVT matrix.
*
* Identical fixture and methodology to sim/read-snm/testbench/tb_read_snm.spice
* (see that file's header for the full rationale on why this is a
* device-level replica of bitcell_6t.spice's half-cell rather than a
* `.include` of the black-box subcircuit, and why one inverter's sweep is
* sufficient to build the full butterfly curve). The only difference from
* the read-SNM fixture is WL: here it is held deasserted (0V), matching
* the standby/retention condition spec/sram.md defines hold SNM against
* ("the cell in standby (wordline deasserted, bit lines
* floating/precharged, no access in progress)") -- the access transistor
* is present (as it physically is) but not loading the storage node.
*
* Corner selection: see ./corner.inc, generated by
* sim/lib/run_corner_sweep.sh -- same mechanism as tb_read_snm.spice.
.include './corner.inc'

.param VIN_STOP='VDDC'

VVDD VDD 0 DC VDDC
VSS VSS 0 DC 0
VIN IN 0 DC 0
VBL BLLOAD 0 DC VDDC
VWL WL 0 DC 0

XMP OUT IN VDD VDD pfet_03v3 L=0.28u W=0.22u nf=1 ad='int((nf+1)/2) * W/nf * 0.18u' as='int((nf+2)/2) * W/nf * 0.18u' pd='2*int((nf+1)/2) * (W/nf + 0.18u)'
+ ps='2*int((nf+2)/2) * (W/nf + 0.18u)' nrd='0.18u / W' nrs='0.18u / W' sa=0 sb=0 sd=0 m=1
XMN OUT IN VSS VSS nfet_03v3 L=0.28u W=0.36u nf=1 ad='int((nf+1)/2) * W/nf * 0.18u' as='int((nf+2)/2) * W/nf * 0.18u' pd='2*int((nf+1)/2) * (W/nf + 0.18u)'
+ ps='2*int((nf+2)/2) * (W/nf + 0.18u)' nrd='0.18u / W' nrs='0.18u / W' sa=0 sb=0 sd=0 m=1
XMA BLLOAD WL OUT VSS nfet_03v3 L=0.28u W=0.24u nf=1 ad='int((nf+1)/2) * W/nf * 0.18u' as='int((nf+2)/2) * W/nf * 0.18u' pd='2*int((nf+1)/2) * (W/nf + 0.18u)'
+ ps='2*int((nf+2)/2) * (W/nf + 0.18u)' nrd='0.18u / W' nrs='0.18u / W' sa=0 sb=0 sd=0 m=1

.dc VIN 0 {VIN_STOP} 0.005

.control
run
wrdata hold_snm_sweep.txt v(OUT)
.endc
.end
