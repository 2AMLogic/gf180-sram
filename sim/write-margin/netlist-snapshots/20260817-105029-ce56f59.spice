* Write margin testbench -- bitcell_6t, DUT netlist `.include`d directly.
*
* Claim under test: spec/sram.md "Characterization" -- write margin, one of
* the four ratified measurements, swept across the 9-corner PVT matrix.
* Defined here as spec/sram.md's "write trip voltage" variant: "the
* minimum bit-line / write-driver drive ... that successfully flips the
* cell's stored value within the write pulse width." This testbench finds
* the write trip voltage (WTV) -- the weakest (closest-to-VDD) "0" the
* write driver can present on the losing bit line and still flip the
* cell -- and reports it, alongside the corner's VDD for context. WTV is
* itself the recorded margin, in volts: a real write driver presents 0 V on
* the losing bit line, so WTV is exactly the head-room that driver has
* before the write stops working, and spec/sram.md's "positive margin at
* every corner" applies to it verbatim. (Neither this file nor
* sim/lib/run_corner_sweep.sh derives any other quantity from the two
* RESULT lines; both are recorded as measured.)
*
* DUT: design/netlist/bitcell_6t.spice, `.include`d flat (its own
* `.subckt`/`.ends` wrapper is commented out by xschem's netlister because
* it was netlisted as a standalone top-level schematic -- see
* design/README.md "Regenerating the netlists" -- so `.include`ing it
* directly exposes its internal storage nodes Q, QB as ordinary top-level
* nets alongside its BL, BLB, WL, VDD, VSS ports). That direct access is
* what write-margin and access-time need and read/hold SNM do not (see
* sim/read-snm/testbench/tb_read_snm.spice's header for why those two
* still need a decoupled device-level replica instead).
*
* Corner selection: see ./corner.inc, generated by
* sim/lib/run_corner_sweep.sh.
.include './corner.inc'

VVDD VDD 0 DC VDDC

* Phase 1 [0, 2n]: preset the cell to '1' (Q=VDD, QB=0) with a strong,
*   full-VDD differential write pulse -- establishes a known starting
*   state without relying on `.ic` on a node this testbench does not
*   directly control the solver's view of (Q/QB come from the `.include`d
*   DUT, and a real preset write is the physically realistic way to reach
*   a known state anyway, not just a simulation convenience).
* Phase 2 idle [2n, 4n]: WL deasserted.
* Phase 3 [4n, 6n]: the write-margin trial. BLB drives a strong '1';
*   BL drives VWRITE -- the "weak 0" whose strength the .control loop
*   below sweeps from 0V (strongest) toward VDDC (weakest, i.e. no write
*   at all). WL asserted for the trial's duration.
.param VWRITE=0
VBL BL 0 PWL(0 VDDC 4n VDDC 4.1n VWRITE 5.9n VWRITE 6n VDDC 8n VDDC)
VBLB BLB 0 PWL(0 0 4n 0 4.1n VDDC 8n VDDC)
VWL WL 0 PWL(0 0 0.1n VDDC 1.9n VDDC 2n 0 4n 0 4.1n VDDC 5.9n VDDC 6n 0 8n 0)

* `@@REPO_ROOT@@` is substituted with this checkout's absolute path by
* sim/lib/run_corner_sweep.sh before each corner run (this testbench runs
* from a per-corner scratch directory, so a repo-relative path would not
* resolve there); running this file directly with plain `ngspice -b`
* instead of through the runner requires substituting it yourself first.
.include '@@REPO_ROOT@@/design/netlist/bitcell_6t.spice'

.control
* Pull the corner's actual VDD into control-language scope (`.param`
* values are not directly readable from `let` expressions in ngspice;
* @<source>[dc] is the documented way to recover one -- see
* sim/README.md "ngspice control-language notes").
let vddc_ctl = @vvdd[dc]

* Write-trip-voltage search: BISECTION over VWRITE on [0, VDD].
*
* Monotonicity assumption (the same one any "first failing trial point"
* linear scan makes implicitly, stated here explicitly because bisection
* makes it load-bearing): the write succeeds for every VWRITE at or below
* the trip point and fails above it -- a weaker '0' on the losing bit line
* never *helps* a write that a stronger '0' could not do.
*
* Why bisection and not the 41-point linear scan this file originally used:
* a linear scan resolves the trip point only to VDD/40 (~83 mV at 3.3 V),
* which is *coarser than the mismatch-induced spread the Monte Carlo
* campaign (issue #26) has to measure*. Every draw at a corner then
* quantized onto the same grid point: the sample standard deviation came
* out at 5e-16 V and Cpk at 1.3e15, i.e. a measurement whose resolution
* swamps the effect under study. The search was replaced rather than the
* claim weakened. 14 bisection steps resolve the trip point to VDD/2^14
* (~0.2 mV at 3.3 V) in 16 transient runs total -- ~400x finer than the old
* scan while also being cheaper than its 41 runs.
*
* Every vector this block uses is created BEFORE the first `tran`. That is
* deliberate, not stylistic: a `let` that first creates a vector *after* an
* analysis has run binds it to that analysis's plot, and a later `$&name`
* substitution then expands to nothing (silently, with no diagnostic --
* `alterparam VWRITE =` with an empty right-hand side simply leaves VWRITE
* at its previous value, so the search appears to run and returns a wrong
* answer). Pre-creating them keeps every name in one plot for the whole
* search. See sim/README.md "ngspice control-language notes".
let vw_lo = 0
let vw_hi = vddc_ctl
let vw_mid = 0
let q_lo = 0
let q_hi = 0
let q_mid = 0
let iter = 0
let wtv_bits = 14
* 2^wtv_bits, written out so the two can be checked against each other by
* eye rather than trusting operator precedence in the control language.
let wtv_resolution = vddc_ctl/16384
let wtv_fail = 0 - wtv_resolution

* Endpoint check 1: the strongest possible '0' (BL pulled to ground).
alterparam VWRITE = 0
reset
tran 0.02n 8n
let q_lo = v(Q)[length(v(Q))-1]

* Endpoint check 2: no differential at all (BL held at VDD). A cell that
* "writes" here is non-physical -- reported as an open result below.
alterparam VWRITE = $&vddc_ctl
reset
tran 0.02n 8n
let q_hi = v(Q)[length(v(Q))-1]

dowhile iter < wtv_bits
  let vw_mid = (vw_lo + vw_hi)/2
  alterparam VWRITE = $&vw_mid
  reset
  tran 0.02n 8n
  let q_mid = v(Q)[length(v(Q))-1]
  * A successful write of '0' leaves Q below VDD/2 at the end of the trial
  * window. Keep `vw_lo` as the strongest-known-succeeding trial and
  * `vw_hi` as the weakest-known-failing one; the interval halves every
  * iteration and `vw_lo` converges up onto the trip point from below, so
  * the reported WTV is still "the weakest '0' that STILL succeeds" --
  * never an interpolated or optimistic value.
  if q_mid <= (vddc_ctl/2)
    let vw_lo = vw_mid
  else
    let vw_hi = vw_mid
  end
  let iter = iter + 1
end

* q_lo failing means the cell never flipped, not even at VWRITE = 0 (the
* strongest '0' a write driver can present). Such a draw has NO write
* margin: the trip point lies below this search's floor. It is recorded as
* the negative of the search resolution -- the smallest strictly negative
* value this search can express, and therefore a resolution-limited upper
* bound on a negative margin. NOT a magic sentinel, and deliberately not an
* "errored" sample either: that distinction is load-bearing for the Monte
* Carlo campaign (sim/lib/run_mc_campaign.py), because an unwritable draw
* is a spec failure that must be *counted* in the yield, whereas an errored
* draw is excluded from every statistic -- reporting this case as an error
* would silently delete exactly the failures a yield campaign exists to
* find.
*
* q_hi succeeding is the opposite pathology: the write "succeeded" with no
* bit-line differential at all, which no functioning bitcell does. That
* stays an explicit open result rather than a fabricated number.
if q_lo > (vddc_ctl/2)
  echo RESULT: write_trip_voltage_v = $&wtv_fail
  echo RESULT: write_vdd_v = $&vddc_ctl
else
  if q_hi <= (vddc_ctl/2)
    echo RESULT-ERROR: write_trip_voltage -- write succeeded even with no bit-line differential (VWRITE = VDD); fixture or corner did not produce a valid trip point
  else
    echo RESULT: write_trip_voltage_v = $&vw_lo
    echo RESULT: write_vdd_v = $&vddc_ctl
  end
end
.endc
.end
