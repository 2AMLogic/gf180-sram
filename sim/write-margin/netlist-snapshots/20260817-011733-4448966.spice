* Write margin testbench -- bitcell_6t, DUT netlist `.include`d directly.
*
* Claim under test: spec/sram.md "Characterization" -- write margin, one of
* the four ratified measurements, swept across the 9-corner PVT matrix.
* Defined here as spec/sram.md's "write trip voltage" variant: "the
* minimum bit-line / write-driver drive ... that successfully flips the
* cell's stored value within the write pulse width." This testbench finds
* the write trip voltage (WTV) -- the weakest (closest-to-VDD) "0" the
* write driver can present on the losing bit line and still flip the
* cell -- and reports it; margin = VDD - WTV is computed by
* sim/lib/run_corner_sweep.sh from the two RESULT lines this testbench
* prints (both in volts, so the subtraction needs no unit conversion).
*
* DUT: design/netlist/bitcell_6t.spice, `.include`d flat (its own
* `.subckt`/`.ends` wrapper is commented out by xschem's netlister because
* it was netlisted as a standalone top-level schematic -- see
* design/README.md "Regenerating the netlists" -- so `.include`ing it
* directly exposes its internal storage nodes Q, QB as ordinary top-level
* nets alongside its BL, BLB, WL, VDD, VSS ports). That direct access is
* what write-margin and access-time need and read/hold SNM do not (see
* sim/read-snm/testbench/tb_read_snm.spice's header for why those two
* still need a decoupled device-level replica instead).
*
* Corner selection: see ./corner.inc, generated by
* sim/lib/run_corner_sweep.sh.
.include './corner.inc'

VVDD VDD 0 DC VDDC

* Phase 1 [0, 2n]: preset the cell to '1' (Q=VDD, QB=0) with a strong,
*   full-VDD differential write pulse -- establishes a known starting
*   state without relying on `.ic` on a node this testbench does not
*   directly control the solver's view of (Q/QB come from the `.include`d
*   DUT, and a real preset write is the physically realistic way to reach
*   a known state anyway, not just a simulation convenience).
* Phase 2 idle [2n, 4n]: WL deasserted.
* Phase 3 [4n, 6n]: the write-margin trial. BLB drives a strong '1';
*   BL drives VWRITE -- the "weak 0" whose strength the .control loop
*   below sweeps from 0V (strongest) toward VDDC (weakest, i.e. no write
*   at all). WL asserted for the trial's duration.
.param VWRITE=0
VBL BL 0 PWL(0 VDDC 4n VDDC 4.1n VWRITE 5.9n VWRITE 6n VDDC 8n VDDC)
VBLB BLB 0 PWL(0 0 4n 0 4.1n VDDC 8n VDDC)
VWL WL 0 PWL(0 0 0.1n VDDC 1.9n VDDC 2n 0 4n 0 4.1n VDDC 5.9n VDDC 6n 0 8n 0)

* `@@REPO_ROOT@@` is substituted with this checkout's absolute path by
* sim/lib/run_corner_sweep.sh before each corner run (this testbench runs
* from a per-corner scratch directory, so a repo-relative path would not
* resolve there); running this file directly with plain `ngspice -b`
* instead of through the runner requires substituting it yourself first.
.include '@@REPO_ROOT@@/design/netlist/bitcell_6t.spice'

.control
* Pull the corner's actual VDD into control-language scope (`.param`
* values are not directly readable from `let` expressions in ngspice;
* @<source>[dc] is the documented way to recover one -- see
* sim/README.md "ngspice control-language notes").
let vddc_ctl = @vvdd[dc]
let vw = 0
let step = vddc_ctl/40
let wtv_found = 0
let wtv = -1
dowhile vw <= vddc_ctl
  alterparam VWRITE = $&vw
  reset
  tran 0.02n 8n
  let qfinal = v(Q)[length(v(Q))-1]
  * A successful write of '0' leaves Q below VDD/2 at the end of the
  * trial window; the first vw where it does NOT is the trip point.
  if qfinal > (vddc_ctl/2) & wtv_found = 0
    let wtv = vw
    let wtv_found = 1
  end
  let vw = vw + step
end
* wtv_found=0 after the full sweep means the write succeeded even at the
* weakest trial point (vw = vddc_ctl, i.e. BL held at VDD, no differential
* at all) -- not physically possible for a functioning bitcell, so report
* it as an explicit open result rather than a fabricated number.
if wtv_found = 0
  echo RESULT-ERROR: write_trip_voltage -- write succeeded at every trial point up to VDD; fixture or corner did not produce a valid trip point
else
  echo RESULT: write_trip_voltage_v = $&wtv
  echo RESULT: write_vdd_v = $&vddc_ctl
end
.endc
.end
