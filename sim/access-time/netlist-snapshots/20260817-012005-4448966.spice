* Write access time testbench -- bitcell_6t, DUT netlist `.include`d
* directly.
*
* Claim under test: spec/sram.md "Characterization" -- read/write access
* time, one of the four ratified measurements, swept across the 9-corner
* PVT matrix. This file is the write half; see tb_read_access_time.spice
* for the read half and its proxy-metric rationale (this file measures
* the internal storage node Q directly, since a write's "completion" is
* the cell's own state changing -- no sense-amp proxy is needed here the
* way it is for a read).
*
* DUT: design/netlist/bitcell_6t.spice, `.include`d flat -- see
* sim/write-margin/testbench/tb_write_margin.spice's header for why this
* is legitimate.
*
* Corner selection: see ./corner.inc, generated by
* sim/lib/run_corner_sweep.sh.
.include './corner.inc'

VVDD VDD 0 DC VDDC

* Write driver: full-strength (write-margin's own testbench separately
* characterizes how weak a driver can be and still succeed -- this
* testbench measures the *speed* of a driver strong enough to always
* succeed, matching how access time is normally characterized: at the
* macro's rated drive strength, not at its margin boundary).
VBL BL 0 PWL(0 VDDC 5n VDDC)
VBLB BLB 0 PWL(0 0 5n 0)

* WL asserted at t=1.1n, writing '1' into a cell preset to '0'.
VWL WL 0 PWL(0 0 1n 0 1.1n VDDC 5n VDDC)

* `@@REPO_ROOT@@` is substituted with this checkout's absolute path by
* sim/lib/run_corner_sweep.sh before each corner run -- see
* tb_write_margin.spice's header for why.
.include '@@REPO_ROOT@@/design/netlist/bitcell_6t.spice'

* Preset to '0' via .ic + uic -- see tb_read_access_time.spice's header
* for why this testbench does not rely on the initial DC operating-point
* solve for a cross-coupled pair.
.ic v(Q)=0 v(QB)='VDDC'
.tran 0.005n 5n uic

.control
run
* Pull the corner's actual VDD into control-language scope -- see
* tb_read_access_time.spice's header for why `.param` isn't directly
* readable here.
let vddc_ctl = @vvdd[dc]
let vddc_half = vddc_ctl/2
meas tran write_access_time trig v(wl) val=$&vddc_half rise=1 targ v(Q) val=$&vddc_half rise=1
echo RESULT: write_access_time_s = $&write_access_time
.endc
.end
