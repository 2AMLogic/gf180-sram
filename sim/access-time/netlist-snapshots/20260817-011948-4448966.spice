* Read access time testbench -- bitcell_6t, DUT netlist `.include`d directly.
*
* Claim under test: spec/sram.md "Characterization" -- read/write access
* time, one of the four ratified measurements, swept across the 9-corner
* PVT matrix. This file is the read half; see tb_write_access_time.spice
* for the write half.
*
* Proxy definition (no periphery exists yet to measure against): this
* macro's array core (design/sram_256x32_array.sch, per design/README.md)
* is storage cells only -- address decode, column mux, sense amp, and
* write driver are explicitly out of scope for the design issue that
* produced it (#21) and have not been drawn. "Valid Q output" per
* spec/sram.md therefore has no sense-amp output to measure yet. This
* testbench instead measures the bitcell-level primitive spec/sram.md
* itself allows for ("a representative column/bitcell testbench where
* full-array simulation is impractical"): the delay from wordline
* assertion to the precharged bit-line pair developing a defined sensing
* differential -- 3% of VDD (~100 mV at the nominal 3.30V corner, scaled
* per-corner so the threshold stays a consistent fraction of the swept
* supply), a conservative, commonly-cited minimum offset a real sense amp
* would need. Once a real sense amp is designed (a downstream issue),
* replace this proxy with a true clock-to-Q measurement through that
* circuit.
*
* DUT: design/netlist/bitcell_6t.spice, `.include`d flat -- see
* sim/write-margin/testbench/tb_write_margin.spice's header for why this
* is legitimate (its `.subckt` wrapper is commented out by xschem's
* netlister for a standalone-netlisted schematic).
*
* Corner selection: see ./corner.inc, generated by
* sim/lib/run_corner_sweep.sh.
.include './corner.inc'

VVDD VDD 0 DC VDDC

* Bit-line switch model: closed (Ron) while the PRE control node is above
* Vt, open (Roff) once precharge is released -- models a real precharge
* device's cutoff, not just an idealized voltage clamp, so the bit line
* is genuinely high-impedance (only its own capacitance) during the read
* window that follows.
.model swmod SW(Ron=10 Roff=1e12 Vt='VDDC/2' Vh='VDDC*0.03')

* Bit-line capacitance: a single-bitcell-column stand-in (this testbench
* measures one cell, not the full 256-row array of design/sram_256x32_array.sch,
* per spec/sram.md's "representative column/bitcell" allowance -- a full
* 256-row column's real bit-line capacitance is a layout-derived quantity
* this schematic-level testbench does not have; 20fF is a conservative
* single-cell-scale placeholder documented here so a future post-layout
* re-run (per spec/sram.md's post-layout re-sim item) can replace it with
* an extracted value without needing to change this testbench's structure).
CBL BL 0 20f
CBLB BLB 0 20f

* Precharge: BL/BLB pulled to VDD through the switches until t=1n, then
* released (PRE falls) to float for the read.
VPRE PRE 0 PWL(0 VDDC 1n VDDC 1.02n 0 5n 0)
VPCHRAIL PCHRAIL 0 DC VDDC
SBL BL PCHRAIL PRE 0 swmod
SBLB BLB PCHRAIL PRE 0 swmod

* WL asserted at t=1.1n, immediately after precharge release -- the read
* access under test.
VWL WL 0 PWL(0 0 1n 0 1.1n VDDC 5n VDDC)

* `@@REPO_ROOT@@` is substituted with this checkout's absolute path by
* sim/lib/run_corner_sweep.sh before each corner run -- see
* tb_write_margin.spice's header for why.
.include '@@REPO_ROOT@@/design/netlist/bitcell_6t.spice'

* Preset the cell to a known state ('0': Q=0, QB=VDD) directly via .ic,
* skipping the initial DC operating-point solve (`uic`): a cross-coupled
* pair's symmetric DC solve can converge to the unstable metastable point
* instead of either real stable corner, so this testbench starts from an
* explicit, known state rather than depending on that solve landing
* somewhere useful.
.ic v(Q)=0 v(QB)='VDDC'
.tran 0.005n 5n uic

.control
run
* Pull the corner's actual VDD into control-language scope (`.param`
* values are not directly readable from `meas`'s trig/targ val= in a
* .control block -- see sim/README.md "ngspice control-language notes").
let vddc_ctl = @vvdd[dc]
let vddc_half = vddc_ctl/2
let vddc_sense = vddc_ctl*0.03
let bldiff = abs(v(bl) - v(blb))
meas tran read_access_time trig v(wl) val=$&vddc_half rise=1 targ bldiff val=$&vddc_sense rise=1
echo RESULT: read_access_time_s = $&read_access_time
.endc
.end
